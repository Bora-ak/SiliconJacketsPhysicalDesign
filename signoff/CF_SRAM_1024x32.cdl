* Empty LVS stub for CF_SRAM_1024x32 (black-boxed in Pegasus via lvs_black_box)
* Ports from inputs/CF_SRAM_1024x32/lef/CF_SRAM_1024x32.lef
.SUBCKT CF_SRAM_1024x32
+ DO[31]
+ DO[30]
+ DO[29]
+ DO[28]
+ DO[27]
+ DO[26]
+ DO[25]
+ DO[24]
+ DO[23]
+ DO[22]
+ DO[21]
+ DO[20]
+ DO[19]
+ DO[18]
+ DO[17]
+ DO[16]
+ DO[15]
+ DO[14]
+ DO[13]
+ DO[12]
+ DO[11]
+ DO[10]
+ DO[9]
+ DO[8]
+ DO[7]
+ DO[6]
+ DO[5]
+ DO[4]
+ DO[3]
+ DO[2]
+ DO[1]
+ DO[0]
+ DI[31]
+ DI[30]
+ DI[29]
+ DI[28]
+ DI[27]
+ DI[26]
+ DI[25]
+ DI[24]
+ DI[23]
+ DI[22]
+ DI[21]
+ DI[20]
+ DI[19]
+ DI[18]
+ DI[17]
+ DI[16]
+ DI[15]
+ DI[14]
+ DI[13]
+ DI[12]
+ DI[11]
+ DI[10]
+ DI[9]
+ DI[8]
+ DI[7]
+ DI[6]
+ DI[5]
+ DI[4]
+ DI[3]
+ DI[2]
+ DI[1]
+ DI[0]
+ BEN[31]
+ BEN[30]
+ BEN[29]
+ BEN[28]
+ BEN[27]
+ BEN[26]
+ BEN[25]
+ BEN[24]
+ BEN[23]
+ BEN[22]
+ BEN[21]
+ BEN[20]
+ BEN[19]
+ BEN[18]
+ BEN[17]
+ BEN[16]
+ BEN[15]
+ BEN[14]
+ BEN[13]
+ BEN[12]
+ BEN[11]
+ BEN[10]
+ BEN[9]
+ BEN[8]
+ BEN[7]
+ BEN[6]
+ BEN[5]
+ BEN[4]
+ BEN[3]
+ BEN[2]
+ BEN[1]
+ BEN[0]
+ AD[9]
+ AD[8]
+ AD[7]
+ AD[6]
+ AD[5]
+ AD[4]
+ AD[3]
+ AD[2]
+ AD[1]
+ AD[0]
+ ScanOutCC
+ CLKin
+ EN
+ R_WB
+ ScanInCC
+ ScanInDL
+ ScanInDR
+ SM
+ TM
+ WLBI
+ WLOFF
+ vgnd
+ vnb
+ vpb
+ vpwra
+ vpwrac
+ vpwrm
+ vpwrp
+ vpwrpc
.ENDS CF_SRAM_1024x32
