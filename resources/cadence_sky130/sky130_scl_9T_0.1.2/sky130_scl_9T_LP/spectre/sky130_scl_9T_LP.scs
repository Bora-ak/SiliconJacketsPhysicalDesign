// sky130_scl_9T_LP/XOR2X4_LP/schematic
subckt XOR2X4_LP A B VDD VSS Y
    mn1 (n2 B VSS VSS) nfet_01v8 w=(420n) l=150n m=(1)*(1)
    mn0 (n1 A VSS VSS) nfet_01v8 w=(420n) l=150n m=(1)*(1)
    mn5 (Y n0 VSS VSS) nfet_01v8 w=(840n) l=150n m=(1)*(2)
    mn3 (n0 B net131 VSS) nfet_01v8 w=(420n) l=150n m=(1)*(1)
    mn4 (n0 n2 n1 VSS) nfet_01v8 w=(420n) l=150n m=(1)*(1)
    mn2 (net131 n1 VSS VSS) nfet_01v8 w=(420n) l=150n m=(1)*(1)
    mp3 (n0 n2 net130 VDD) pfet_01v8_hvt w=625n l=150n m=1
    mp1 (n2 B VDD VDD) pfet_01v8_hvt w=(620n) l=150n m=(1)*(1)
    mp4 (n1 B n0 VDD) pfet_01v8_hvt w=(620n) l=150n m=(1)*(1)
    mp0 (n1 A VDD VDD) pfet_01v8_hvt w=(620n) l=150n m=(1)*(1)
    mp5 (Y n0 VDD VDD) pfet_01v8_hvt w=625n l=150n m=1
    mp2 (net130 n1 VDD VDD) pfet_01v8_hvt w=(620n) l=150n m=(1)*(1)
ends XOR2X4_LP

// sky130_scl_9T_LP/XOR2X2_LP/schematic
subckt XOR2X2_LP A B VDD VSS Y
    mn1 (n2 B VSS VSS) nfet_01v8 w=(420n) l=150n m=(1)*(1)
    mn0 (n1 A VSS VSS) nfet_01v8 w=(420n) l=150n m=(1)*(1)
    mn5 (Y n0 VSS VSS) nfet_01v8 w=(840n) l=150n m=(1)*(1)
    mn3 (n0 B net131 VSS) nfet_01v8 w=(420n) l=150n m=(1)*(1)
    mn4 (n0 n2 n1 VSS) nfet_01v8 w=(420n) l=150n m=(1)*(1)
    mn2 (net131 n1 VSS VSS) nfet_01v8 w=(420n) l=150n m=(1)*(1)
    mp3 (n0 n2 net130 VDD) pfet_01v8_hvt w=625n l=150n m=1
    mp1 (n2 B VDD VDD) pfet_01v8_hvt w=(540n) l=150n m=(1)*(1)
    mp4 (n1 B n0 VDD) pfet_01v8_hvt w=(540n) l=150n m=(1)*(1)
    mp0 (n1 A VDD VDD) pfet_01v8_hvt w=(540n) l=150n m=(1)*(1)
    mp5 (Y n0 VDD VDD) pfet_01v8_hvt w=625n l=150n m=1
    mp2 (net130 n1 VDD VDD) pfet_01v8_hvt w=(540n) l=150n m=(1)*(1)
ends XOR2X2_LP

// sky130_scl_9T_LP/XOR2X1_LP/schematic
subckt XOR2X1_LP A B VDD VSS Y
    mn1 (n2 B VSS VSS) nfet_01v8 w=(420n) l=150n m=(1)*(1)
    mn0 (n1 A VSS VSS) nfet_01v8 w=(420n) l=150n m=(1)*(1)
    mn5 (Y n0 VSS VSS) nfet_01v8 w=(420n) l=150n m=(1)*(1)
    mn3 (n0 B net131 VSS) nfet_01v8 w=(420n) l=150n m=(1)*(1)
    mn4 (n0 n2 n1 VSS) nfet_01v8 w=(420n) l=150n m=(1)*(1)
    mn2 (net131 n1 VSS VSS) nfet_01v8 w=(420n) l=150n m=(1)*(1)
    mp3 (n0 n2 net130 VDD) pfet_01v8_hvt w=625n l=150n m=1
    mp1 (n2 B VDD VDD) pfet_01v8_hvt w=(540n) l=150n m=(1)*(1)
    mp4 (n1 B n0 VDD) pfet_01v8_hvt w=(540n) l=150n m=(1)*(1)
    mp0 (n1 A VDD VDD) pfet_01v8_hvt w=(540n) l=150n m=(1)*(1)
    mp5 (Y n0 VDD VDD) pfet_01v8_hvt w=625n l=150n m=1
    mp2 (net130 n1 VDD VDD) pfet_01v8_hvt w=(540n) l=150n m=(1)*(1)
ends XOR2X1_LP

// sky130_scl_9T_LP/XNOR2X4_LP/schematic
subckt XNOR2X4_LP A B VDD VSS Y
    mn1 (n2 B VSS VSS) nfet_01v8 w=(420n) l=150n m=(1)*(1)
    mn2 (net145 n1 VSS VSS) nfet_01v8 w=(420n) l=150n m=(1)*(1)
    mn3 (n0 n2 net145 VSS) nfet_01v8 w=(420n) l=150n m=(1)*(1)
    mn5 (Y n0 VSS VSS) nfet_01v8 w=(840n) l=150n m=(1)*(2)
    mn0 (n1 A VSS VSS) nfet_01v8 w=(420n) l=150n m=(1)*(1)
    mn4 (n0 B n1 VSS) nfet_01v8 w=(420n) l=150n m=(1)*(1)
    mp0 (n1 A VDD VDD) pfet_01v8_hvt w=(620n) l=150n m=(1)*(1)
    mp4 (n1 n2 n0 VDD) pfet_01v8_hvt w=(620n) l=150n m=(1)*(1)
    mp2 (net112 n1 VDD VDD) pfet_01v8_hvt w=625n l=150n m=1
    mp1 (n2 B VDD VDD) pfet_01v8_hvt w=625n l=150n m=1
    mp3 (n0 B net112 VDD) pfet_01v8_hvt w=(620n) l=150n m=(1)*(1)
    mp5 (Y n0 VDD VDD) pfet_01v8_hvt w=625n l=150n m=1
ends XNOR2X4_LP

// sky130_scl_9T_LP/XNOR2X2_LP/schematic
subckt XNOR2X2_LP A B VDD VSS Y
    mn1 (n2 B VSS VSS) nfet_01v8 w=(420n) l=150n m=(1)*(1)
    mn2 (net145 n1 VSS VSS) nfet_01v8 w=(420n) l=150n m=(1)*(1)
    mn3 (n0 n2 net145 VSS) nfet_01v8 w=(420n) l=150n m=(1)*(1)
    mn5 (Y n0 VSS VSS) nfet_01v8 w=(840n) l=150n m=(1)*(1)
    mn0 (n1 A VSS VSS) nfet_01v8 w=(420n) l=150n m=(1)*(1)
    mn4 (n0 B n1 VSS) nfet_01v8 w=(420n) l=150n m=(1)*(1)
    mp0 (n1 A VDD VDD) pfet_01v8_hvt w=(540n) l=150n m=(1)*(1)
    mp4 (n1 n2 n0 VDD) pfet_01v8_hvt w=(540n) l=150n m=(1)*(1)
    mp2 (net112 n1 VDD VDD) pfet_01v8_hvt w=(540n) l=150n m=(1)*(1)
    mp1 (n2 B VDD VDD) pfet_01v8_hvt w=(540n) l=150n m=(1)*(1)
    mp3 (n0 B net112 VDD) pfet_01v8_hvt w=625n l=150n m=1
    mp5 (Y n0 VDD VDD) pfet_01v8_hvt w=625n l=150n m=1
ends XNOR2X2_LP

// sky130_scl_9T_LP/XNOR2X1_LP/schematic
subckt XNOR2X1_LP A B VDD VSS Y
    mn1 (n2 B VSS VSS) nfet_01v8 w=(420n) l=150n m=(1)*(1)
    mn2 (net145 n1 VSS VSS) nfet_01v8 w=(420n) l=150n m=(1)*(1)
    mn3 (n0 n2 net145 VSS) nfet_01v8 w=(420n) l=150n m=(1)*(1)
    mn5 (Y n0 VSS VSS) nfet_01v8 w=(420n) l=150n m=(1)*(1)
    mn0 (n1 A VSS VSS) nfet_01v8 w=(420n) l=150n m=(1)*(1)
    mn4 (n0 B n1 VSS) nfet_01v8 w=(420n) l=150n m=(1)*(1)
    mp0 (n1 A VDD VDD) pfet_01v8_hvt w=(540n) l=150n m=(1)*(1)
    mp4 (n1 n2 n0 VDD) pfet_01v8_hvt w=(540n) l=150n m=(1)*(1)
    mp2 (net112 n1 VDD VDD) pfet_01v8_hvt w=(540n) l=150n m=(1)*(1)
    mp1 (n2 B VDD VDD) pfet_01v8_hvt w=(540n) l=150n m=(1)*(1)
    mp3 (n0 B net112 VDD) pfet_01v8_hvt w=1.13u l=150n m=1
    mp5 (Y n0 VDD VDD) pfet_01v8_hvt w=1.13u l=150n m=1
ends XNOR2X1_LP

// sky130_scl_9T_LP/TLATX1_LP/schematic
subckt TLATX1_LP D G Q QN VDD VSS
    mn26 (n0 Gbb n21 VSS) nfet_01v8 w=(420n) l=150n m=(1)*(1)
    mn25 (n21 D VSS VSS) nfet_01v8 w=(420n) l=150n m=(1)*(1)
    mn57 (QN Qint VSS VSS) nfet_01v8 w=(420n) l=150n m=(1)*(1)
    mn55 (Qbint Qint VSS VSS) nfet_01v8 w=(420n) l=150n m=(1)*(1)
    mn35 (n25 Qint VSS VSS) nfet_01v8 w=(420n) l=150n m=(1)*(1)
    mn36 (n0 Gb n25 VSS) nfet_01v8 w=(420n) l=150n m=(1)*(1)
    mn20 (Gb G VSS VSS) nfet_01v8 w=(420n) l=150n m=(1)*(1)
    mn56 (Q Qbint VSS VSS) nfet_01v8 w=(420n) l=150n m=(1)*(1)
    mn21 (Gbb Gb VSS VSS) nfet_01v8 w=(420n) l=150n m=(1)*(1)
    mn30 (Qint n0 VSS VSS) nfet_01v8 w=(420n) l=150n m=(1)*(1)
    mp26 (n0 Gb n22 VDD) pfet_01v8_hvt w=(540n) l=150n m=(1)*(1)
    mp25 (n22 D VDD VDD) pfet_01v8_hvt w=(540n) l=150n m=(1)*(1)
    mp57 (QN Qint VDD VDD) pfet_01v8_hvt w=(620n) l=150n m=(1)*(1)
    mp55 (Qbint Qint VDD VDD) pfet_01v8_hvt w=625n l=150n m=1
    mp35 (n26 Qint VDD VDD) pfet_01v8_hvt w=(540n) l=150n m=(1)*(1)
    mp36 (n0 Gbb n26 VDD) pfet_01v8_hvt w=625n l=150n m=1
    mp20 (Gb G VDD VDD) pfet_01v8_hvt w=(540n) l=150n m=(1)*(1)
    mp56 (Q Qbint VDD VDD) pfet_01v8_hvt w=(620n) l=150n m=(1)*(1)
    mp21 (Gbb Gb VDD VDD) pfet_01v8_hvt w=(540n) l=150n m=(1)*(1)
    mp30 (Qint n0 VDD VDD) pfet_01v8_hvt w=(540n) l=150n m=(1)*(1)
ends TLATX1_LP

// sky130_scl_9T_LP/TLATSRX1_LP/schematic
subckt TLATSRX1_LP D G Q QN RN SN VDD VSS
    mn26 (n0 Gbb n21 VSS) nfet_01v8 w=(420n) l=150n m=(1)*(1)
    mn25 (n21 D VSS VSS) nfet_01v8 w=(420n) l=150n m=(1)*(1)
    mn57 (QN Qint VSS VSS) nfet_01v8 w=(420n) l=150n m=(1)*(1)
    mn55 (Qbint Qint VSS VSS) nfet_01v8 w=(420n) l=150n m=(1)*(1)
    mn35 (n25 Qint net3 VSS) nfet_01v8 w=(420n) l=150n m=(1)*(1)
    mn36 (n0 Gb n25 VSS) nfet_01v8 w=(420n) l=150n m=(1)*(1)
    mn20 (Gb G net1 VSS) nfet_01v8 w=(420n) l=150n m=(1)*(1)
    NM0 (net1 RN VSS VSS) nfet_01v8 w=(420n) l=150n m=(1)*(1)
    mn56 (Q Qbint VSS VSS) nfet_01v8 w=(420n) l=150n m=(1)*(1)
    mn21 (Gbb Gb VSS VSS) nfet_01v8 w=(420n) l=150n m=(1)*(1)
    mn30 (Qint n0 net2 VSS) nfet_01v8 w=(420n) l=150n m=(1)*(1)
    NM1 (net2 SN VSS VSS) nfet_01v8 w=(420n) l=150n m=(1)*(1)
    NM2 (net3 RN VSS VSS) nfet_01v8 w=(420n) l=150n m=(1)*(1)
    PM0 (Gb RN VDD VDD) pfet_01v8_hvt w=(540n) l=150n m=(1)*(1)
    PM1 (Qint SN VDD VDD) pfet_01v8_hvt w=(540n) l=150n m=(1)*(1)
    mp26 (n0 Gb n22 VDD) pfet_01v8_hvt w=(540n) l=150n m=(1)*(1)
    mp25 (n22 D VDD VDD) pfet_01v8_hvt w=(540n) l=150n m=(1)*(1)
    mp57 (QN Qint VDD VDD) pfet_01v8_hvt w=(620n) l=150n m=(1)*(1)
    mp55 (Qbint Qint VDD VDD) pfet_01v8_hvt w=(620n) l=150n m=(1)*(1)
    mp35 (n26 Qint VDD VDD) pfet_01v8_hvt w=(540n) l=150n m=(1)*(1)
    mp36 (n0 Gbb n26 VDD) pfet_01v8_hvt w=1.13u l=150n m=1
    mp20 (Gb G VDD VDD) pfet_01v8_hvt w=(540n) l=150n m=(1)*(1)
    mp56 (Q Qbint VDD VDD) pfet_01v8_hvt w=1.13u l=150n m=1
    mp21 (Gbb Gb VDD VDD) pfet_01v8_hvt w=(540n) l=150n m=(1)*(1)
    PM2 (n26 RN VDD VDD) pfet_01v8_hvt w=(540n) l=150n m=(1)*(1)
    mp30 (Qint n0 VDD VDD) pfet_01v8_hvt w=(540n) l=150n m=(1)*(1)
ends TLATSRX1_LP

// sky130_scl_9T_LP/TBUFX8_LP/schematic
subckt TBUFX8_LP A OE VDD VSS Y
    mn5 (Y non VSS VSS) nfet_01v8 w=(420n) l=150n m=(1)*(8)
    mn3 (net144 A VSS VSS) nfet_01v8 w=(420n) l=150n m=(1)*(2)
    mn0 (OEb OE VSS VSS) nfet_01v8 w=(420n) l=150n m=(1)*(1)
    mn4 (pon OE net144 VSS) nfet_01v8 w=(420n) l=150n m=(1)*(2)
    mn2 (non OEb VSS VSS) nfet_01v8 w=(420n) l=150n m=(1)*(2)
    mn1 (non A VSS VSS) nfet_01v8 w=(420n) l=150n m=(1)*(2)
    mp2 (non OEb net127 VDD) pfet_01v8_hvt w=625n l=150n m=1
    mp1 (net127 A VDD VDD) pfet_01v8_hvt w=(620n) l=150n m=(1)*(2)
    mp5 (Y pon VDD VDD) pfet_01v8_hvt w=625n l=150n m=1
    mp3 (pon A VDD VDD) pfet_01v8_hvt w=(620n) l=150n m=(1)*(2)
    mp4 (pon OE VDD VDD) pfet_01v8_hvt w=(620n) l=150n m=(1)*(2)
    mp0 (OEb OE VDD VDD) pfet_01v8_hvt w=625n l=150n m=1
ends TBUFX8_LP

// sky130_scl_9T_LP/TBUFX4_LP/schematic
subckt TBUFX4_LP A OE VDD VSS Y
    mn5 (Y non VSS VSS) nfet_01v8 w=(420n) l=150n m=(1)*(4)
    mn3 (net144 A VSS VSS) nfet_01v8 w=(420n) l=150n m=(1)*(1)
    mn0 (OEb OE VSS VSS) nfet_01v8 w=(420n) l=150n m=(1)*(1)
    mn4 (pon OE net144 VSS) nfet_01v8 w=(420n) l=150n m=(1)*(1)
    mn2 (non OEb VSS VSS) nfet_01v8 w=(420n) l=150n m=(1)*(1)
    mn1 (non A VSS VSS) nfet_01v8 w=(420n) l=150n m=(1)*(1)
    mp2 (non OEb net127 VDD) pfet_01v8_hvt w=625n l=150n m=1
    mp1 (net127 A VDD VDD) pfet_01v8_hvt w=(620n) l=150n m=(1)*(1)
    mp5 (Y pon VDD VDD) pfet_01v8_hvt w=625n l=150n m=1
    mp3 (pon A VDD VDD) pfet_01v8_hvt w=(620n) l=150n m=(1)*(1)
    mp4 (pon OE VDD VDD) pfet_01v8_hvt w=(620n) l=150n m=(1)*(1)
    mp0 (OEb OE VDD VDD) pfet_01v8_hvt w=625n l=150n m=1
ends TBUFX4_LP

// sky130_scl_9T_LP/TBUFX1_LP/schematic
subckt TBUFX1_LP A OE VDD VSS Y
    mn5 (Y non VSS VSS) nfet_01v8 w=(420n) l=150n m=(1)*(1)
    mn3 (net144 A VSS VSS) nfet_01v8 w=(420n) l=150n m=(1)*(1)
    mn0 (OEb OE VSS VSS) nfet_01v8 w=(420n) l=150n m=(1)*(1)
    mn4 (pon OE net144 VSS) nfet_01v8 w=(420n) l=150n m=(1)*(1)
    mn2 (non OEb VSS VSS) nfet_01v8 w=(420n) l=150n m=(1)*(1)
    mn1 (non A VSS VSS) nfet_01v8 w=(420n) l=150n m=(1)*(1)
    mp2 (non OEb net127 VDD) pfet_01v8_hvt w=1.13u l=150n m=1
    mp1 (net127 A VDD VDD) pfet_01v8_hvt w=(540n) l=150n m=(1)*(1)
    mp5 (Y pon VDD VDD) pfet_01v8_hvt w=1.13u l=150n m=1
    mp3 (pon A VDD VDD) pfet_01v8_hvt w=(540n) l=150n m=(1)*(1)
    mp4 (pon OE VDD VDD) pfet_01v8_hvt w=(540n) l=150n m=(1)*(1)
    mp0 (OEb OE VDD VDD) pfet_01v8_hvt w=(540n) l=150n m=(1)*(1)
ends TBUFX1_LP

// sky130_scl_9T_LP/SDFFX4_LP/schematic
subckt SDFFX4_LP CK D Q QN SE SI VDD VSS
    mn13 (net461 SI VSS VSS) nfet_01v8 w=(420n) l=150n m=(1)*(1)
    mn14 (Db SE net461 VSS) nfet_01v8 w=(420n) l=150n m=(1)*(1)
    mn12 (Db SEb net449 VSS) nfet_01v8 w=(420n) l=150n m=(1)*(1)
    mn11 (net449 D VSS VSS) nfet_01v8 w=(420n) l=150n m=(1)*(1)
    mn57 (QN net367 VSS VSS) nfet_01v8 w=(420n) l=150n m=(1)*(4)
    mn55 (Q qbint VSS VSS) nfet_01v8 w=(420n) l=150n m=(1)*(4)
    mn50 (net436 qbint VSS VSS) nfet_01v8 w=(420n) l=150n m=(1)*(1)
    mn51 (n30 CKb net436 VSS) nfet_01v8 w=(420n) l=150n m=(1)*(1)
    mn35 (net429 mout VSS VSS) nfet_01v8 w=(420n) l=150n m=(1)*(1)
    mn36 (n20 CKbb net429 VSS) nfet_01v8 w=(420n) l=150n m=(1)*(1)
    mn20 (CKb CK VSS VSS) nfet_01v8 w=(420n) l=150n m=(1)*(1)
    mn45 (qbint n30 VSS VSS) nfet_01v8 w=(420n) l=150n m=(1)*(2)
    mn56 (net367 qbint VSS VSS) nfet_01v8 w=(420n) l=150n m=(1)*(1)
    mn21 (CKbb CKb VSS VSS) nfet_01v8 w=(420n) l=150n m=(1)*(1)
    mn40 (n30 CKbb mout VSS) nfet_01v8 w=(420n) l=150n m=(1)*(1)
    mn30 (mout n20 VSS VSS) nfet_01v8 w=(420n) l=150n m=(1)*(1)
    mn10 (SEb SE VSS VSS) nfet_01v8 w=(420n) l=150n m=(1)*(1)
    mn25 (n20 CKb Db VSS) nfet_01v8 w=(420n) l=150n m=(1)*(1)
    mp14 (Db SEb net392 VDD) pfet_01v8_hvt w=(540n) l=150n m=(1)*(1)
    mp13 (net392 SI VDD VDD) pfet_01v8_hvt w=(540n) l=150n m=(1)*(1)
    mp12 (Db SE net384 VDD) pfet_01v8_hvt w=(540n) l=150n m=(1)*(1)
    mp11 (net384 D VDD VDD) pfet_01v8_hvt w=(540n) l=150n m=(1)*(1)
    mp51 (n30 CKbb net376 VDD) pfet_01v8_hvt w=(540n) l=150n m=(1)*(1)
    mp50 (net376 qbint VDD VDD) pfet_01v8_hvt w=(540n) l=150n m=(1)*(1)
    mp57 (QN net367 VDD VDD) pfet_01v8_hvt w=(620n) l=150n m=(1)*(4)
    mp55 (Q qbint VDD VDD) pfet_01v8_hvt w=625n l=150n m=1
    mp35 (net356 mout VDD VDD) pfet_01v8_hvt w=(540n) l=150n m=(1)*(1)
    mp36 (n20 CKb net356 VDD) pfet_01v8_hvt w=625n l=150n m=1
    mp20 (CKb CK VDD VDD) pfet_01v8_hvt w=(540n) l=150n m=(1)*(1)
    mp45 (qbint n30 VDD VDD) pfet_01v8_hvt w=625n l=150n m=1
    mp56 (net367 qbint VDD VDD) pfet_01v8_hvt w=625n l=150n m=1
    mp21 (CKbb CKb VDD VDD) pfet_01v8_hvt w=(540n) l=150n m=(1)*(1)
    mp40 (n30 CKb mout VDD) pfet_01v8_hvt w=(540n) l=150n m=(1)*(1)
    mp30 (mout n20 VDD VDD) pfet_01v8_hvt w=(540n) l=150n m=(1)*(1)
    mp25 (n20 CKbb Db VDD) pfet_01v8_hvt w=(540n) l=150n m=(1)*(1)
    mp10 (SEb SE VDD VDD) pfet_01v8_hvt w=(540n) l=150n m=(1)*(1)
ends SDFFX4_LP

// sky130_scl_9T_LP/SDFFX1_LP/schematic
subckt SDFFX1_LP CK D Q QN SE SI VDD VSS
    mn13 (net461 SI VSS VSS) nfet_01v8 w=(420n) l=150n m=(1)*(1)
    mn14 (Db SE net461 VSS) nfet_01v8 w=(420n) l=150n m=(1)*(1)
    mn12 (Db SEb net449 VSS) nfet_01v8 w=(420n) l=150n m=(1)*(1)
    mn11 (net449 D VSS VSS) nfet_01v8 w=(420n) l=150n m=(1)*(1)
    mn57 (QN net367 VSS VSS) nfet_01v8 w=(420n) l=150n m=(1)*(1)
    mn55 (Q qbint VSS VSS) nfet_01v8 w=(420n) l=150n m=(1)*(1)
    mn50 (net436 qbint VSS VSS) nfet_01v8 w=(420n) l=150n m=(1)*(1)
    mn51 (n30 CKb net436 VSS) nfet_01v8 w=(420n) l=150n m=(1)*(1)
    mn35 (net429 mout VSS VSS) nfet_01v8 w=(420n) l=150n m=(1)*(1)
    mn36 (n20 CKbb net429 VSS) nfet_01v8 w=(420n) l=150n m=(1)*(1)
    mn20 (CKb CK VSS VSS) nfet_01v8 w=(420n) l=150n m=(1)*(1)
    mn45 (qbint n30 VSS VSS) nfet_01v8 w=(420n) l=150n m=(1)*(1)
    mn56 (net367 qbint VSS VSS) nfet_01v8 w=(420n) l=150n m=(1)*(1)
    mn21 (CKbb CKb VSS VSS) nfet_01v8 w=(420n) l=150n m=(1)*(1)
    mn40 (n30 CKbb mout VSS) nfet_01v8 w=(420n) l=150n m=(1)*(1)
    mn30 (mout n20 VSS VSS) nfet_01v8 w=(420n) l=150n m=(1)*(1)
    mn10 (SEb SE VSS VSS) nfet_01v8 w=(420n) l=150n m=(1)*(1)
    mn25 (n20 CKb Db VSS) nfet_01v8 w=(420n) l=150n m=(1)*(1)
    mp14 (Db SEb net392 VDD) pfet_01v8_hvt w=(540n) l=150n m=(1)*(1)
    mp13 (net392 SI VDD VDD) pfet_01v8_hvt w=(540n) l=150n m=(1)*(1)
    mp12 (Db SE net384 VDD) pfet_01v8_hvt w=(540n) l=150n m=(1)*(1)
    mp11 (net384 D VDD VDD) pfet_01v8_hvt w=(540n) l=150n m=(1)*(1)
    mp51 (n30 CKbb net376 VDD) pfet_01v8_hvt w=(540n) l=150n m=(1)*(1)
    mp50 (net376 qbint VDD VDD) pfet_01v8_hvt w=(540n) l=150n m=(1)*(1)
    mp57 (QN net367 VDD VDD) pfet_01v8_hvt w=(620n) l=150n m=(1)*(1)
    mp55 (Q qbint VDD VDD) pfet_01v8_hvt w=1.13u l=150n m=1
    mp35 (net356 mout VDD VDD) pfet_01v8_hvt w=(540n) l=150n m=(1)*(1)
    mp36 (n20 CKb net356 VDD) pfet_01v8_hvt w=1.13u l=150n m=1
    mp20 (CKb CK VDD VDD) pfet_01v8_hvt w=(540n) l=150n m=(1)*(1)
    mp45 (qbint n30 VDD VDD) pfet_01v8_hvt w=(540n) l=150n m=(1)*(1)
    mp56 (net367 qbint VDD VDD) pfet_01v8_hvt w=(540n) l=150n m=(1)*(1)
    mp21 (CKbb CKb VDD VDD) pfet_01v8_hvt w=(540n) l=150n m=(1)*(1)
    mp40 (n30 CKb mout VDD) pfet_01v8_hvt w=(540n) l=150n m=(1)*(1)
    mp30 (mout n20 VDD VDD) pfet_01v8_hvt w=(540n) l=150n m=(1)*(1)
    mp25 (n20 CKbb Db VDD) pfet_01v8_hvt w=(540n) l=150n m=(1)*(1)
    mp10 (SEb SE VDD VDD) pfet_01v8_hvt w=(540n) l=150n m=(1)*(1)
ends SDFFX1_LP

// sky130_scl_9T_LP/SDFFSX4_LP/schematic
subckt SDFFSX4_LP CK D Q QN SE SI SN VDD VSS
    mn51 (net518 qbint net521 VSS) nfet_01v8 w=(420n) l=150n m=(1)*(1)
    mn52 (n35 CKb net518 VSS) nfet_01v8 w=(420n) l=150n m=(1)*(1)
    mn50 (net521 SN VSS VSS) nfet_01v8 w=(420n) l=150n m=(1)*(1)
    mn13 (net506 SI VSS VSS) nfet_01v8 w=(420n) l=150n m=(1)*(1)
    mn14 (Db SE net506 VSS) nfet_01v8 w=(420n) l=150n m=(1)*(1)
    mn12 (Db SEb net494 VSS) nfet_01v8 w=(420n) l=150n m=(1)*(1)
    mn11 (net494 D VSS VSS) nfet_01v8 w=(420n) l=150n m=(1)*(1)
    mn57 (QN net492 VSS VSS) nfet_01v8 w=(420n) l=150n m=(1)*(4)
    mn55 (Q qbint VSS VSS) nfet_01v8 w=(420n) l=150n m=(1)*(4)
    mn31 (mout n20 net442 VSS) nfet_01v8 w=(420n) l=150n m=(1)*(1)
    mn35 (net478 mout VSS VSS) nfet_01v8 w=(420n) l=150n m=(1)*(1)
    mn36 (n20 CKbb net478 VSS) nfet_01v8 w=(420n) l=150n m=(1)*(1)
    mn20 (CKb CK VSS VSS) nfet_01v8 w=(420n) l=150n m=(1)*(1)
    mn45 (qbint n35 VSS VSS) nfet_01v8 w=(420n) l=150n m=(1)*(2)
    mn56 (net492 qbint VSS VSS) nfet_01v8 w=(420n) l=150n m=(1)*(1)
    mn21 (CKbb CKb VSS VSS) nfet_01v8 w=(420n) l=150n m=(1)*(1)
    mn40 (n35 CKbb mout VSS) nfet_01v8 w=(420n) l=150n m=(1)*(1)
    mn10 (SEb SE VSS VSS) nfet_01v8 w=(420n) l=150n m=(1)*(1)
    mn25 (Db CKb n20 VSS) nfet_01v8 w=(420n) l=150n m=(1)*(1)
    mn30 (net442 SN VSS VSS) nfet_01v8 w=(420n) l=150n m=(1)*(1)
    mp14 (Db SEb net441 VDD) pfet_01v8_hvt w=(540n) l=150n m=(1)*(1)
    mp13 (net441 SI VDD VDD) pfet_01v8_hvt w=(540n) l=150n m=(1)*(1)
    mp12 (Db SE net433 VDD) pfet_01v8_hvt w=(540n) l=150n m=(1)*(1)
    mp11 (net433 D VDD VDD) pfet_01v8_hvt w=(540n) l=150n m=(1)*(1)
    mp57 (QN net492 VDD VDD) pfet_01v8_hvt w=(620n) l=150n m=(1)*(4)
    mp55 (Q qbint VDD VDD) pfet_01v8_hvt w=625n l=150n m=1
    mp36 (n20 CKb net417 VDD) pfet_01v8_hvt w=625n l=150n m=1
    mp35 (net417 mout VDD VDD) pfet_01v8_hvt w=(540n) l=150n m=(1)*(1)
    mp20 (CKb CK VDD VDD) pfet_01v8_hvt w=(540n) l=150n m=(1)*(1)
    mp52 (n35 CKbb net405 VDD) pfet_01v8_hvt w=(540n) l=150n m=(1)*(1)
    mp51 (net405 qbint VDD VDD) pfet_01v8_hvt w=(540n) l=150n m=(1)*(1)
    mp50 (net405 SN VDD VDD) pfet_01v8_hvt w=(540n) l=150n m=(1)*(1)
    mp45 (qbint n35 VDD VDD) pfet_01v8_hvt w=625n l=150n m=1
    mp56 (net492 qbint VDD VDD) pfet_01v8_hvt w=625n l=150n m=1
    mp21 (CKbb CKb VDD VDD) pfet_01v8_hvt w=(540n) l=150n m=(1)*(1)
    mp40 (n35 CKb mout VDD) pfet_01v8_hvt w=(540n) l=150n m=(1)*(1)
    mp30 (mout SN VDD VDD) pfet_01v8_hvt w=(540n) l=150n m=(1)*(1)
    mp31 (mout n20 VDD VDD) pfet_01v8_hvt w=(540n) l=150n m=(1)*(1)
    mp25 (n20 CKbb Db VDD) pfet_01v8_hvt w=(540n) l=150n m=(1)*(1)
    mp10 (SEb SE VDD VDD) pfet_01v8_hvt w=(540n) l=150n m=(1)*(1)
ends SDFFSX4_LP

// sky130_scl_9T_LP/SDFFSX1_LP/schematic
subckt SDFFSX1_LP CK D Q QN SE SI SN VDD VSS
    mn51 (net518 qbint net521 VSS) nfet_01v8 w=(420n) l=150n m=(1)*(1)
    mn52 (n35 CKb net518 VSS) nfet_01v8 w=(420n) l=150n m=(1)*(1)
    mn50 (net521 SN VSS VSS) nfet_01v8 w=(420n) l=150n m=(1)*(1)
    mn13 (net506 SI VSS VSS) nfet_01v8 w=(420n) l=150n m=(1)*(1)
    mn14 (Db SE net506 VSS) nfet_01v8 w=(420n) l=150n m=(1)*(1)
    mn12 (Db SEb net494 VSS) nfet_01v8 w=(420n) l=150n m=(1)*(1)
    mn11 (net494 D VSS VSS) nfet_01v8 w=(420n) l=150n m=(1)*(1)
    mn57 (QN net492 VSS VSS) nfet_01v8 w=(420n) l=150n m=(1)*(1)
    mn55 (Q qbint VSS VSS) nfet_01v8 w=(420n) l=150n m=(1)*(1)
    mn31 (mout n20 net442 VSS) nfet_01v8 w=(420n) l=150n m=(1)*(1)
    mn35 (net478 mout VSS VSS) nfet_01v8 w=(420n) l=150n m=(1)*(1)
    mn36 (n20 CKbb net478 VSS) nfet_01v8 w=(420n) l=150n m=(1)*(1)
    mn20 (CKb CK VSS VSS) nfet_01v8 w=(420n) l=150n m=(1)*(1)
    mn45 (qbint n35 VSS VSS) nfet_01v8 w=(420n) l=150n m=(1)*(1)
    mn56 (net492 qbint VSS VSS) nfet_01v8 w=(420n) l=150n m=(1)*(1)
    mn21 (CKbb CKb VSS VSS) nfet_01v8 w=(420n) l=150n m=(1)*(1)
    mn40 (n35 CKbb mout VSS) nfet_01v8 w=(420n) l=150n m=(1)*(1)
    mn10 (SEb SE VSS VSS) nfet_01v8 w=(420n) l=150n m=(1)*(1)
    mn25 (Db CKb n20 VSS) nfet_01v8 w=(420n) l=150n m=(1)*(1)
    mn30 (net442 SN VSS VSS) nfet_01v8 w=(420n) l=150n m=(1)*(1)
    mp14 (Db SEb net441 VDD) pfet_01v8_hvt w=(540n) l=150n m=(1)*(1)
    mp13 (net441 SI VDD VDD) pfet_01v8_hvt w=(540n) l=150n m=(1)*(1)
    mp12 (Db SE net433 VDD) pfet_01v8_hvt w=(540n) l=150n m=(1)*(1)
    mp11 (net433 D VDD VDD) pfet_01v8_hvt w=(540n) l=150n m=(1)*(1)
    mp57 (QN net492 VDD VDD) pfet_01v8_hvt w=(620n) l=150n m=(1)*(1)
    mp55 (Q qbint VDD VDD) pfet_01v8_hvt w=1.13u l=150n m=1
    mp36 (n20 CKb net417 VDD) pfet_01v8_hvt w=1.13u l=150n m=1
    mp35 (net417 mout VDD VDD) pfet_01v8_hvt w=(540n) l=150n m=(1)*(1)
    mp20 (CKb CK VDD VDD) pfet_01v8_hvt w=(540n) l=150n m=(1)*(1)
    mp52 (n35 CKbb net405 VDD) pfet_01v8_hvt w=(540n) l=150n m=(1)*(1)
    mp51 (net405 qbint VDD VDD) pfet_01v8_hvt w=(540n) l=150n m=(1)*(1)
    mp50 (net405 SN VDD VDD) pfet_01v8_hvt w=(540n) l=150n m=(1)*(1)
    mp45 (qbint n35 VDD VDD) pfet_01v8_hvt w=(540n) l=150n m=(1)*(1)
    mp56 (net492 qbint VDD VDD) pfet_01v8_hvt w=(540n) l=150n m=(1)*(1)
    mp21 (CKbb CKb VDD VDD) pfet_01v8_hvt w=(540n) l=150n m=(1)*(1)
    mp40 (n35 CKb mout VDD) pfet_01v8_hvt w=(540n) l=150n m=(1)*(1)
    mp30 (mout SN VDD VDD) pfet_01v8_hvt w=(540n) l=150n m=(1)*(1)
    mp31 (mout n20 VDD VDD) pfet_01v8_hvt w=(540n) l=150n m=(1)*(1)
    mp25 (n20 CKbb Db VDD) pfet_01v8_hvt w=(540n) l=150n m=(1)*(1)
    mp10 (SEb SE VDD VDD) pfet_01v8_hvt w=(540n) l=150n m=(1)*(1)
ends SDFFSX1_LP

// sky130_scl_9T_LP/SDFFSRX4_LP/schematic
subckt SDFFSRX4_LP CK D Q QN RN SE SI SN VDD VSS
    mn13 (n2 SI VSS VSS) nfet_01v8 w=(420n) l=150n m=(1)*(1)
    mn14 (Db SE n2 VSS) nfet_01v8 w=(420n) l=150n m=(1)*(1)
    mn12 (Db SEb n0 VSS) nfet_01v8 w=(420n) l=150n m=(1)*(1)
    mn11 (n0 D VSS VSS) nfet_01v8 w=(420n) l=150n m=(1)*(1)
    mn57 (QN net573 VSS VSS) nfet_01v8 w=(420n) l=150n m=(1)*(4)
    mn55 (Q qbint VSS VSS) nfet_01v8 w=(420n) l=150n m=(1)*(4)
    mn35 (n6 mout VSS VSS) nfet_01v8 w=(420n) l=150n m=(1)*(1)
    mn36 (n20 CKbb n6 VSS) nfet_01v8 w=(420n) l=150n m=(1)*(1)
    mn22 (RNb RN VSS VSS) nfet_01v8 w=(420n) l=150n m=(1)*(1)
    mn20 (CKb CK VSS VSS) nfet_01v8 w=(420n) l=150n m=(1)*(1)
    mn10 (SEb SE VSS VSS) nfet_01v8 w=(420n) l=150n m=(1)*(1)
    mn56 (net573 qbint VSS VSS) nfet_01v8 w=(420n) l=150n m=(1)*(1)
    mn25 (Db CKb n20 VSS) nfet_01v8 w=(420n) l=150n m=(1)*(1)
    mn32 (mout n20 n4 VSS) nfet_01v8 w=(420n) l=150n m=(1)*(1)
    mn53 (n35 CKb n10 VSS) nfet_01v8 w=(420n) l=150n m=(1)*(1)
    mn30 (n4 SN VSS VSS) nfet_01v8 w=(420n) l=150n m=(1)*(1)
    mn50 (n8 SN VSS VSS) nfet_01v8 w=(420n) l=150n m=(1)*(1)
    mn51 (n10 RNb n8 VSS) nfet_01v8 w=(420n) l=150n m=(1)*(1)
    mn40 (n35 CKbb mout VSS) nfet_01v8 w=(420n) l=150n m=(1)*(1)
    mn31 (mout RNb n4 VSS) nfet_01v8 w=(420n) l=150n m=(1)*(1)
    mn21 (CKbb CKb VSS VSS) nfet_01v8 w=(420n) l=150n m=(1)*(1)
    mn52 (n10 qbint n8 VSS) nfet_01v8 w=(420n) l=150n m=(1)*(1)
    mn45 (qbint n35 VSS VSS) nfet_01v8 w=(420n) l=150n m=(1)*(2)
    mp14 (Db SEb n3 VDD) pfet_01v8_hvt w=(540n) l=150n m=(1)*(1)
    mp13 (n3 SI VDD VDD) pfet_01v8_hvt w=(540n) l=150n m=(1)*(1)
    mp12 (Db SE n1 VDD) pfet_01v8_hvt w=(540n) l=150n m=(1)*(1)
    mp11 (n1 D VDD VDD) pfet_01v8_hvt w=(540n) l=150n m=(1)*(1)
    mp52 (n11 qbint n9 VDD) pfet_01v8_hvt w=(540n) l=150n m=(1)*(1)
    mp51 (n9 RNb VDD VDD) pfet_01v8_hvt w=(540n) l=150n m=(1)*(1)
    mp57 (QN net573 VDD VDD) pfet_01v8_hvt w=(620n) l=150n m=(1)*(4)
    mp55 (Q qbint VDD VDD) pfet_01v8_hvt w=625n l=150n m=1
    mp36 (n20 CKb n7 VDD) pfet_01v8_hvt w=(540n) l=150n m=(1)*(1)
    mp35 (n7 mout VDD VDD) pfet_01v8_hvt w=(540n) l=150n m=(1)*(1)
    mp32 (mout n20 n5 VDD) pfet_01v8_hvt w=625n l=150n m=1
    mp31 (n5 RNb VDD VDD) pfet_01v8_hvt w=(540n) l=150n m=(1)*(1)
    mp22 (RNb RN VDD VDD) pfet_01v8_hvt w=(540n) l=150n m=(1)*(1)
    mp20 (CKb CK VDD VDD) pfet_01v8_hvt w=(540n) l=150n m=(1)*(1)
    mp21 (CKbb CKb VDD VDD) pfet_01v8_hvt w=(540n) l=150n m=(1)*(1)
    mp45 (qbint n35 VDD VDD) pfet_01v8_hvt w=625n l=150n m=1
    mp30 (mout SN VDD VDD) pfet_01v8_hvt w=(540n) l=150n m=(1)*(1)
    mp25 (n20 CKbb Db VDD) pfet_01v8_hvt w=(540n) l=150n m=(1)*(1)
    mp56 (net573 qbint VDD VDD) pfet_01v8_hvt w=625n l=150n m=1
    mp40 (n35 CKb mout VDD) pfet_01v8_hvt w=(540n) l=150n m=(1)*(1)
    mp53 (n35 CKbb n11 VDD) pfet_01v8_hvt w=(540n) l=150n m=(1)*(1)
    mp50 (n11 SN VDD VDD) pfet_01v8_hvt w=(540n) l=150n m=(1)*(1)
    mp10 (SEb SE VDD VDD) pfet_01v8_hvt w=(540n) l=150n m=(1)*(1)
ends SDFFSRX4_LP

// sky130_scl_9T_LP/SDFFSRX1_LP/schematic
subckt SDFFSRX1_LP CK D Q QN RN SE SI SN VDD VSS
    mn13 (n2 SI VSS VSS) nfet_01v8 w=(420n) l=150n m=(1)*(1)
    mn14 (Db SE n2 VSS) nfet_01v8 w=(420n) l=150n m=(1)*(1)
    mn12 (Db SEb n0 VSS) nfet_01v8 w=(420n) l=150n m=(1)*(1)
    mn11 (n0 D VSS VSS) nfet_01v8 w=(420n) l=150n m=(1)*(1)
    mn57 (QN net573 VSS VSS) nfet_01v8 w=(420n) l=150n m=(1)*(1)
    mn55 (Q qbint VSS VSS) nfet_01v8 w=(420n) l=150n m=(1)*(1)
    mn35 (n6 mout VSS VSS) nfet_01v8 w=(420n) l=150n m=(1)*(1)
    mn36 (n20 CKbb n6 VSS) nfet_01v8 w=(420n) l=150n m=(1)*(1)
    mn22 (RNb RN VSS VSS) nfet_01v8 w=(420n) l=150n m=(1)*(1)
    mn20 (CKb CK VSS VSS) nfet_01v8 w=(420n) l=150n m=(1)*(1)
    mn10 (SEb SE VSS VSS) nfet_01v8 w=(420n) l=150n m=(1)*(1)
    mn56 (net573 qbint VSS VSS) nfet_01v8 w=(420n) l=150n m=(1)*(1)
    mn25 (Db CKb n20 VSS) nfet_01v8 w=(420n) l=150n m=(1)*(1)
    mn32 (mout n20 n4 VSS) nfet_01v8 w=(420n) l=150n m=(1)*(1)
    mn53 (n35 CKb n10 VSS) nfet_01v8 w=(420n) l=150n m=(1)*(1)
    mn30 (n4 SN VSS VSS) nfet_01v8 w=(420n) l=150n m=(1)*(1)
    mn50 (n8 SN VSS VSS) nfet_01v8 w=(420n) l=150n m=(1)*(1)
    mn51 (n10 RNb n8 VSS) nfet_01v8 w=(420n) l=150n m=(1)*(1)
    mn40 (n35 CKbb mout VSS) nfet_01v8 w=(420n) l=150n m=(1)*(1)
    mn31 (mout RNb n4 VSS) nfet_01v8 w=(420n) l=150n m=(1)*(1)
    mn21 (CKbb CKb VSS VSS) nfet_01v8 w=(420n) l=150n m=(1)*(1)
    mn52 (n10 qbint n8 VSS) nfet_01v8 w=(420n) l=150n m=(1)*(1)
    mn45 (qbint n35 VSS VSS) nfet_01v8 w=(420n) l=150n m=(1)*(1)
    mp14 (Db SEb n3 VDD) pfet_01v8_hvt w=(540n) l=150n m=(1)*(1)
    mp13 (n3 SI VDD VDD) pfet_01v8_hvt w=(540n) l=150n m=(1)*(1)
    mp12 (Db SE n1 VDD) pfet_01v8_hvt w=(540n) l=150n m=(1)*(1)
    mp11 (n1 D VDD VDD) pfet_01v8_hvt w=(540n) l=150n m=(1)*(1)
    mp52 (n11 qbint n9 VDD) pfet_01v8_hvt w=(540n) l=150n m=(1)*(1)
    mp51 (n9 RNb VDD VDD) pfet_01v8_hvt w=(540n) l=150n m=(1)*(1)
    mp57 (QN net573 VDD VDD) pfet_01v8_hvt w=(620n) l=150n m=(1)*(1)
    mp55 (Q qbint VDD VDD) pfet_01v8_hvt w=1.13u l=150n m=4
    mp36 (n20 CKb n7 VDD) pfet_01v8_hvt w=(540n) l=150n m=(1)*(1)
    mp35 (n7 mout VDD VDD) pfet_01v8_hvt w=(540n) l=150n m=(1)*(1)
    mp32 (mout n20 n5 VDD) pfet_01v8_hvt w=(540n) l=150n m=(1)*(1)
    mp31 (n5 RNb VDD VDD) pfet_01v8_hvt w=(540n) l=150n m=(1)*(1)
    mp22 (RNb RN VDD VDD) pfet_01v8_hvt w=(540n) l=150n m=(1)*(1)
    mp20 (CKb CK VDD VDD) pfet_01v8_hvt w=(540n) l=150n m=(1)*(1)
    mp21 (CKbb CKb VDD VDD) pfet_01v8_hvt w=(540n) l=150n m=(1)*(1)
    mp45 (qbint n35 VDD VDD) pfet_01v8_hvt w=(540n) l=150n m=(1)*(1)
    mp30 (mout SN VDD VDD) pfet_01v8_hvt w=(540n) l=150n m=(1)*(1)
    mp25 (n20 CKbb Db VDD) pfet_01v8_hvt w=(540n) l=150n m=(1)*(1)
    mp56 (net573 qbint VDD VDD) pfet_01v8_hvt w=(540n) l=150n m=(1)*(1)
    mp40 (n35 CKb mout VDD) pfet_01v8_hvt w=(540n) l=150n m=(1)*(1)
    mp53 (n35 CKbb n11 VDD) pfet_01v8_hvt w=1.13u l=150n m=4
    mp50 (n11 SN VDD VDD) pfet_01v8_hvt w=(540n) l=150n m=(1)*(1)
    mp10 (SEb SE VDD VDD) pfet_01v8_hvt w=(540n) l=150n m=(1)*(1)
ends SDFFSRX1_LP

// sky130_scl_9T_LP/SDFFRX4_LP/schematic
subckt SDFFRX4_LP CK D Q QN RN SE SI VDD VSS
    mn36 (n5 mout n7 VSS) nfet_01v8 w=(420n) l=150n m=(1)*(1)
    mn35 (n7 RN VSS VSS) nfet_01v8 w=(420n) l=150n m=(1)*(1)
    mn37 (n20 Ckbb n5 VSS) nfet_01v8 w=(420n) l=150n m=(1)*(1)
    mn13 (n3 SI VSS VSS) nfet_01v8 w=(420n) l=150n m=(1)*(1)
    mn14 (Db SE n3 VSS) nfet_01v8 w=(420n) l=150n m=(1)*(1)
    mn12 (Db SEb n1 VSS) nfet_01v8 w=(420n) l=150n m=(1)*(1)
    mn11 (n1 D VSS VSS) nfet_01v8 w=(420n) l=150n m=(1)*(1)
    mn57 (QN qint VSS VSS) nfet_01v8 w=(420n) l=150n m=(1)*(4)
    mn55 (Q qbint VSS VSS) nfet_01v8 w=(420n) l=150n m=(1)*(4)
    mn45 (n9 RN VSS VSS) nfet_01v8 w=(420n) l=150n m=(1)*(2)
    mn46 (qbint n30 n9 VSS) nfet_01v8 w=(420n) l=150n m=(1)*(2)
    mn51 (n30 CKb n11 VSS) nfet_01v8 w=(420n) l=150n m=(1)*(1)
    mn50 (n11 qbint VSS VSS) nfet_01v8 w=(420n) l=150n m=(1)*(1)
    mn20 (CKb CK VSS VSS) nfet_01v8 w=(420n) l=150n m=(1)*(1)
    mn56 (qint qbint VSS VSS) nfet_01v8 w=(420n) l=150n m=(1)*(1)
    mn40 (mout Ckbb n30 VSS) nfet_01v8 w=(420n) l=150n m=(1)*(1)
    mn30 (mout n20 VSS VSS) nfet_01v8 w=(420n) l=150n m=(1)*(1)
    mn21 (Ckbb CKb VSS VSS) nfet_01v8 w=(420n) l=150n m=(1)*(1)
    mn10 (SEb SE VSS VSS) nfet_01v8 w=(420n) l=150n m=(1)*(1)
    mn25 (Db CKb n20 VSS) nfet_01v8 w=(420n) l=150n m=(1)*(1)
    mp14 (Db SEb n4 VDD) pfet_01v8_hvt w=(540n) l=150n m=(1)*(1)
    mp13 (n4 SI VDD VDD) pfet_01v8_hvt w=(540n) l=150n m=(1)*(1)
    mp12 (Db SE n2 VDD) pfet_01v8_hvt w=(540n) l=150n m=(1)*(1)
    mp11 (n2 D VDD VDD) pfet_01v8_hvt w=(540n) l=150n m=(1)*(1)
    mp51 (n30 Ckbb n8 VDD) pfet_01v8_hvt w=(540n) l=150n m=(1)*(1)
    mp50 (n8 qbint VDD VDD) pfet_01v8_hvt w=(540n) l=150n m=(1)*(1)
    mp55 (Q qbint VDD VDD) pfet_01v8_hvt w=1.13u l=150n m=1
    mp20 (CKb CK VDD VDD) pfet_01v8_hvt w=(540n) l=150n m=(1)*(1)
    mp46 (qbint n30 VDD VDD) pfet_01v8_hvt w=(540n) l=150n m=(1)*(2)
    mp56 (qint qbint VDD VDD) pfet_01v8_hvt w=1.13u l=150n m=1
    mp45 (qbint RN VDD VDD) pfet_01v8_hvt w=1.13u l=150n m=1
    mp35 (n6 RN VDD VDD) pfet_01v8_hvt w=(540n) l=150n m=(1)*(1)
    mp36 (n6 mout VDD VDD) pfet_01v8_hvt w=(540n) l=150n m=(1)*(1)
    mp37 (n20 CKb n6 VDD) pfet_01v8_hvt w=1.13u l=150n m=1
    mp40 (n30 CKb mout VDD) pfet_01v8_hvt w=(540n) l=150n m=(1)*(1)
    mp30 (mout n20 VDD VDD) pfet_01v8_hvt w=(540n) l=150n m=(1)*(1)
    mp21 (Ckbb CKb VDD VDD) pfet_01v8_hvt w=(540n) l=150n m=(1)*(1)
    mp25 (n20 Ckbb Db VDD) pfet_01v8_hvt w=(540n) l=150n m=(1)*(1)
    mp10 (SEb SE VDD VDD) pfet_01v8_hvt w=(540n) l=150n m=(1)*(1)
    mp57 (QN qint VDD VDD) pfet_01v8_hvt w=(620n) l=150n m=(1)*(4)
ends SDFFRX4_LP

// sky130_scl_9T_LP/SDFFRX1_LP/schematic
subckt SDFFRX1_LP CK D Q QN RN SE SI VDD VSS
    mn36 (n5 mout n7 VSS) nfet_01v8 w=(420n) l=150n m=(1)*(1)
    mn35 (n7 RN VSS VSS) nfet_01v8 w=(420n) l=150n m=(1)*(1)
    mn37 (n20 Ckbb n5 VSS) nfet_01v8 w=(420n) l=150n m=(1)*(1)
    mn13 (n3 SI VSS VSS) nfet_01v8 w=(420n) l=150n m=(1)*(1)
    mn14 (Db SE n3 VSS) nfet_01v8 w=(420n) l=150n m=(1)*(1)
    mn12 (Db SEb n1 VSS) nfet_01v8 w=(420n) l=150n m=(1)*(1)
    mn11 (n1 D VSS VSS) nfet_01v8 w=(420n) l=150n m=(1)*(1)
    mn57 (QN qint VSS VSS) nfet_01v8 w=(420n) l=150n m=(1)*(1)
    mn55 (Q qbint VSS VSS) nfet_01v8 w=(420n) l=150n m=(1)*(1)
    mn45 (n9 RN VSS VSS) nfet_01v8 w=(420n) l=150n m=(1)*(1)
    mn46 (qbint n30 n9 VSS) nfet_01v8 w=(420n) l=150n m=(1)*(1)
    mn51 (n30 CKb n11 VSS) nfet_01v8 w=(420n) l=150n m=(1)*(1)
    mn50 (n11 qbint VSS VSS) nfet_01v8 w=(420n) l=150n m=(1)*(1)
    mn20 (CKb CK VSS VSS) nfet_01v8 w=(420n) l=150n m=(1)*(1)
    mn56 (qint qbint VSS VSS) nfet_01v8 w=(420n) l=150n m=(1)*(1)
    mn40 (mout Ckbb n30 VSS) nfet_01v8 w=(420n) l=150n m=(1)*(1)
    mn30 (mout n20 VSS VSS) nfet_01v8 w=(420n) l=150n m=(1)*(1)
    mn21 (Ckbb CKb VSS VSS) nfet_01v8 w=(420n) l=150n m=(1)*(1)
    mn10 (SEb SE VSS VSS) nfet_01v8 w=(420n) l=150n m=(1)*(1)
    mn25 (Db CKb n20 VSS) nfet_01v8 w=(420n) l=150n m=(1)*(1)
    mp14 (Db SEb n4 VDD) pfet_01v8_hvt w=(540n) l=150n m=(1)*(1)
    mp13 (n4 SI VDD VDD) pfet_01v8_hvt w=(540n) l=150n m=(1)*(1)
    mp12 (Db SE n2 VDD) pfet_01v8_hvt w=(540n) l=150n m=(1)*(1)
    mp11 (n2 D VDD VDD) pfet_01v8_hvt w=(540n) l=150n m=(1)*(1)
    mp51 (n30 Ckbb n8 VDD) pfet_01v8_hvt w=(540n) l=150n m=(1)*(1)
    mp50 (n8 qbint VDD VDD) pfet_01v8_hvt w=(540n) l=150n m=(1)*(1)
    mp55 (Q qbint VDD VDD) pfet_01v8_hvt w=1.13u l=150n m=4
    mp20 (CKb CK VDD VDD) pfet_01v8_hvt w=(540n) l=150n m=(1)*(1)
    mp46 (qbint n30 VDD VDD) pfet_01v8_hvt w=(540n) l=150n m=(1)*(1)
    mp56 (qint qbint VDD VDD) pfet_01v8_hvt w=(540n) l=150n m=(1)*(1)
    mp45 (qbint RN VDD VDD) pfet_01v8_hvt w=(540n) l=150n m=(1)*(1)
    mp35 (n6 RN VDD VDD) pfet_01v8_hvt w=(540n) l=150n m=(1)*(1)
    mp36 (n6 mout VDD VDD) pfet_01v8_hvt w=(540n) l=150n m=(1)*(1)
    mp37 (n20 CKb n6 VDD) pfet_01v8_hvt w=1.13u l=150n m=4
    mp40 (n30 CKb mout VDD) pfet_01v8_hvt w=(540n) l=150n m=(1)*(1)
    mp30 (mout n20 VDD VDD) pfet_01v8_hvt w=(540n) l=150n m=(1)*(1)
    mp21 (Ckbb CKb VDD VDD) pfet_01v8_hvt w=(540n) l=150n m=(1)*(1)
    mp25 (n20 Ckbb Db VDD) pfet_01v8_hvt w=(540n) l=150n m=(1)*(1)
    mp10 (SEb SE VDD VDD) pfet_01v8_hvt w=(540n) l=150n m=(1)*(1)
    mp57 (QN qint VDD VDD) pfet_01v8_hvt w=(620n) l=150n m=(1)*(1)
ends SDFFRX1_LP

// sky130_scl_9T_LP/OR4X2_LP/schematic
subckt OR4X2_LP A B C D VDD VSS Y
    mn4 (Y n0 VSS VSS) nfet_01v8 w=(840n) l=150n m=(1)*(1)
    mn3 (n0 D VSS VSS) nfet_01v8 w=(420n) l=150n m=(1)*(1)
    mn0 (n0 A VSS VSS) nfet_01v8 w=(420n) l=150n m=(1)*(1)
    mn2 (n0 C VSS VSS) nfet_01v8 w=(420n) l=150n m=(1)*(1)
    mn1 (n0 B VSS VSS) nfet_01v8 w=(420n) l=150n m=(1)*(1)
    mp4 (Y n0 VDD VDD) pfet_01v8_hvt w=625n l=150n m=1
    mp0 (n1 A VDD VDD) pfet_01v8_hvt w=(540n) l=150n m=(1)*(1)
    mp3 (n0 D n3 VDD) pfet_01v8_hvt w=625n l=150n m=1
    mp1 (n2 B n1 VDD) pfet_01v8_hvt w=(540n) l=150n m=(1)*(1)
    mp2 (n3 C n2 VDD) pfet_01v8_hvt w=(540n) l=150n m=(1)*(1)
ends OR4X2_LP

// sky130_scl_9T_LP/OR4X1_LP/schematic
subckt OR4X1_LP A B C D VDD VSS Y
    mn4 (Y n0 VSS VSS) nfet_01v8 w=(420n) l=150n m=(1)*(1)
    mn3 (n0 D VSS VSS) nfet_01v8 w=(420n) l=150n m=(1)*(1)
    mn0 (n0 A VSS VSS) nfet_01v8 w=(420n) l=150n m=(1)*(1)
    mn2 (n0 C VSS VSS) nfet_01v8 w=(420n) l=150n m=(1)*(1)
    mn1 (n0 B VSS VSS) nfet_01v8 w=(420n) l=150n m=(1)*(1)
    mp4 (Y n0 VDD VDD) pfet_01v8_hvt w=1.13u l=150n m=2
    mp0 (n1 A VDD VDD) pfet_01v8_hvt w=(540n) l=150n m=(1)*(1)
    mp3 (n0 D n3 VDD) pfet_01v8_hvt w=1.13u l=150n m=2
    mp1 (n2 B n1 VDD) pfet_01v8_hvt w=(540n) l=150n m=(1)*(1)
    mp2 (n3 C n2 VDD) pfet_01v8_hvt w=(540n) l=150n m=(1)*(1)
ends OR4X1_LP

// sky130_scl_9T_LP/OR3X2_LP/schematic
subckt OR3X2_LP A B C VDD VSS Y
    mn3 (Y n0 VSS VSS) nfet_01v8 w=(840n) l=150n m=(1)*(1)
    mn0 (n0 A VSS VSS) nfet_01v8 w=(420n) l=150n m=(1)*(1)
    mn1 (n0 B VSS VSS) nfet_01v8 w=(420n) l=150n m=(1)*(1)
    mn2 (n0 C VSS VSS) nfet_01v8 w=(420n) l=150n m=(1)*(1)
    mp3 (Y n0 VDD VDD) pfet_01v8_hvt w=1.13u l=150n m=1
    mp1 (n2 B n1 VDD) pfet_01v8_hvt w=1.13u l=150n m=1
    mp2 (n0 C n2 VDD) pfet_01v8_hvt w=1.13u l=150n m=1
    mp0 (n1 A VDD VDD) pfet_01v8_hvt w=(540n) l=150n m=(1)*(1)
ends OR3X2_LP

// sky130_scl_9T_LP/OR3X1_LP/schematic
subckt OR3X1_LP A B C VDD VSS Y
    mn3 (Y n0 VSS VSS) nfet_01v8 w=(420n) l=150n m=(1)*(1)
    mn0 (n0 A VSS VSS) nfet_01v8 w=(420n) l=150n m=(1)*(1)
    mn1 (n0 B VSS VSS) nfet_01v8 w=(420n) l=150n m=(1)*(1)
    mn2 (n0 C VSS VSS) nfet_01v8 w=(420n) l=150n m=(1)*(1)
    mp3 (Y n0 VDD VDD) pfet_01v8_hvt w=1.13u l=150n m=2
    mp1 (n2 B n1 VDD) pfet_01v8_hvt w=(540n) l=150n m=(1)*(1)
    mp2 (n0 C n2 VDD) pfet_01v8_hvt w=1.13u l=150n m=2
    mp0 (n1 A VDD VDD) pfet_01v8_hvt w=(540n) l=150n m=(1)*(1)
ends OR3X1_LP

// sky130_scl_9T_LP/OR2X2_LP/schematic
subckt OR2X2_LP A B VDD VSS Y
    mn2 (Y n0 VSS VSS) nfet_01v8 w=(840n) l=150n m=(1)*(1)
    mn0 (n0 A VSS VSS) nfet_01v8 w=(420n) l=150n m=(1)*(1)
    mn1 (n0 B VSS VSS) nfet_01v8 w=(420n) l=150n m=(1)*(1)
    mp1 (n0 B n1 VDD) pfet_01v8_hvt w=1.13u l=150n m=2
    mp2 (Y n0 VDD VDD) pfet_01v8_hvt w=1.13u l=150n m=2
    mp0 (n1 A VDD VDD) pfet_01v8_hvt w=(540n) l=150n m=(1)*(1)
ends OR2X2_LP

// sky130_scl_9T_LP/OR2X1_LP/schematic
subckt OR2X1_LP A B VDD VSS Y
    mn2 (Y n0 VSS VSS) nfet_01v8 w=(420n) l=150n m=(1)*(1)
    mn0 (n0 A VSS VSS) nfet_01v8 w=(420n) l=150n m=(1)*(1)
    mn1 (n0 B VSS VSS) nfet_01v8 w=(420n) l=150n m=(1)*(1)
    mp1 (n0 B n1 VDD) pfet_01v8_hvt w=625n l=150n m=1
    mp2 (Y n0 VDD VDD) pfet_01v8_hvt w=625n l=150n m=1
    mp0 (n1 A VDD VDD) pfet_01v8_hvt w=(540n) l=150n m=(1)*(1)
ends OR2X1_LP

// sky130_scl_9T_LP/OAI22X2_LP/schematic
subckt OAI22X2_LP A0 A1 B0 B1 VDD VSS Y
    mn0 (net102 A0 VSS VSS) nfet_01v8 w=(840n) l=150n m=(1)*(1)
    mn3 (Y B1 net102 VSS) nfet_01v8 w=(840n) l=150n m=(1)*(1)
    mn1 (net102 A1 VSS VSS) nfet_01v8 w=(840n) l=150n m=(1)*(1)
    mn2 (Y B0 net102 VSS) nfet_01v8 w=(840n) l=150n m=(1)*(1)
    mp3 (Y B1 net85 VDD) pfet_01v8_hvt w=(1.24u) l=150n m=(1)*(1)
    mp1 (Y A1 net93 VDD) pfet_01v8_hvt w=1.13u l=150n m=4
    mp0 (net93 A0 VDD VDD) pfet_01v8_hvt w=(1.24u) l=150n m=(1)*(1)
    mp2 (net85 B0 VDD VDD) pfet_01v8_hvt w=(1.24u) l=150n m=(1)*(1)
ends OAI22X2_LP

// sky130_scl_9T_LP/OAI22X1_LP/schematic
subckt OAI22X1_LP A0 A1 B0 B1 VDD VSS Y
    mn0 (net102 A0 VSS VSS) nfet_01v8 w=(420n) l=150n m=(1)*(1)
    mn3 (Y B1 net102 VSS) nfet_01v8 w=(420n) l=150n m=(1)*(1)
    mn1 (net102 A1 VSS VSS) nfet_01v8 w=(420n) l=150n m=(1)*(1)
    mn2 (Y B0 net102 VSS) nfet_01v8 w=(420n) l=150n m=(1)*(1)
    mp3 (Y B1 net85 VDD) pfet_01v8_hvt w=(620n) l=150n m=(1)*(1)
    mp1 (Y A1 net93 VDD) pfet_01v8_hvt w=1.13u l=150n m=1
    mp0 (net93 A0 VDD VDD) pfet_01v8_hvt w=(620n) l=150n m=(1)*(1)
    mp2 (net85 B0 VDD VDD) pfet_01v8_hvt w=(620n) l=150n m=(1)*(1)
ends OAI22X1_LP

// sky130_scl_9T_LP/OAI222X2_LP/schematic
subckt OAI222X2_LP A0 A1 B0 B1 C0 C1 VDD VSS Y
    mn5 (Y C1 n0 VSS) nfet_01v8 w=(840n) l=150n m=(1)*(1)
    mn4 (Y C0 n0 VSS) nfet_01v8 w=(840n) l=150n m=(1)*(1)
    mn3 (n0 B1 n1 VSS) nfet_01v8 w=(840n) l=150n m=(1)*(1)
    mn2 (n0 B0 n1 VSS) nfet_01v8 w=(840n) l=150n m=(1)*(1)
    mn0 (n1 A0 VSS VSS) nfet_01v8 w=(840n) l=150n m=(1)*(1)
    mn1 (n1 A1 VSS VSS) nfet_01v8 w=(840n) l=150n m=(1)*(1)
    mp5 (Y C1 n4 VDD) pfet_01v8_hvt w=(1.24u) l=150n m=(1)*(1)
    mp4 (n4 C0 VDD VDD) pfet_01v8_hvt w=(1.24u) l=150n m=(1)*(1)
    mp3 (Y B1 n3 VDD) pfet_01v8_hvt w=(1.24u) l=150n m=(1)*(1)
    mp2 (n3 B0 VDD VDD) pfet_01v8_hvt w=(1.24u) l=150n m=(1)*(1)
    mp1 (Y A1 n2 VDD) pfet_01v8_hvt w=1.13u l=150n m=2
    mp0 (n2 A0 VDD VDD) pfet_01v8_hvt w=(1.24u) l=150n m=(1)*(1)
ends OAI222X2_LP

// sky130_scl_9T_LP/OAI222X1_LP/schematic
subckt OAI222X1_LP A0 A1 B0 B1 C0 C1 VDD VSS Y
    mn5 (Y C1 n0 VSS) nfet_01v8 w=(420n) l=150n m=(1)*(1)
    mn4 (Y C0 n0 VSS) nfet_01v8 w=(420n) l=150n m=(1)*(1)
    mn3 (n0 B1 n1 VSS) nfet_01v8 w=(420n) l=150n m=(1)*(1)
    mn2 (n0 B0 n1 VSS) nfet_01v8 w=(420n) l=150n m=(1)*(1)
    mn0 (n1 A0 VSS VSS) nfet_01v8 w=(420n) l=150n m=(1)*(1)
    mn1 (n1 A1 VSS VSS) nfet_01v8 w=(420n) l=150n m=(1)*(1)
    mp5 (Y C1 n4 VDD) pfet_01v8_hvt w=(620n) l=150n m=(1)*(1)
    mp4 (n4 C0 VDD VDD) pfet_01v8_hvt w=(620n) l=150n m=(1)*(1)
    mp3 (Y B1 n3 VDD) pfet_01v8_hvt w=(620n) l=150n m=(1)*(1)
    mp2 (n3 B0 VDD VDD) pfet_01v8_hvt w=(620n) l=150n m=(1)*(1)
    mp1 (Y A1 n2 VDD) pfet_01v8_hvt w=1.13u l=150n m=1
    mp0 (n2 A0 VDD VDD) pfet_01v8_hvt w=(620n) l=150n m=(1)*(1)
ends OAI222X1_LP

// sky130_scl_9T_LP/OAI221X2_LP/schematic
subckt OAI221X2_LP A0 A1 B0 B1 C0 VDD VSS Y
    mn4 (Y C0 net132 VSS) nfet_01v8 w=(840n) l=150n m=(1)*(1)
    mn0 (net128 A0 VSS VSS) nfet_01v8 w=(840n) l=150n m=(1)*(1)
    mn1 (net128 A1 VSS VSS) nfet_01v8 w=(840n) l=150n m=(1)*(1)
    mn2 (net132 B0 net128 VSS) nfet_01v8 w=(840n) l=150n m=(1)*(1)
    mn3 (net132 B1 net128 VSS) nfet_01v8 w=(840n) l=150n m=(1)*(1)
    mp3 (Y B1 net123 VDD) pfet_01v8_hvt w=(1.24u) l=150n m=(1)*(1)
    mp0 (net115 A0 VDD VDD) pfet_01v8_hvt w=(1.24u) l=150n m=(1)*(1)
    mp1 (Y A1 net115 VDD) pfet_01v8_hvt w=1.13u l=150n m=1
    mp2 (net123 B0 VDD VDD) pfet_01v8_hvt w=(1.24u) l=150n m=(1)*(1)
    mp4 (Y C0 VDD VDD) pfet_01v8_hvt w=(1.24u) l=150n m=(1)*(1)
ends OAI221X2_LP

// sky130_scl_9T_LP/OAI221X1_LP/schematic
subckt OAI221X1_LP A0 A1 B0 B1 C0 VDD VSS Y
    mn4 (Y C0 net132 VSS) nfet_01v8 w=(420n) l=150n m=(1)*(1)
    mn0 (net128 A0 VSS VSS) nfet_01v8 w=(420n) l=150n m=(1)*(1)
    mn1 (net128 A1 VSS VSS) nfet_01v8 w=(420n) l=150n m=(1)*(1)
    mn2 (net132 B0 net128 VSS) nfet_01v8 w=(420n) l=150n m=(1)*(1)
    mn3 (net132 B1 net128 VSS) nfet_01v8 w=(420n) l=150n m=(1)*(1)
    mp3 (Y B1 net123 VDD) pfet_01v8_hvt w=(620n) l=150n m=(1)*(1)
    mp0 (net115 A0 VDD VDD) pfet_01v8_hvt w=(620n) l=150n m=(1)*(1)
    mp1 (Y A1 net115 VDD) pfet_01v8_hvt w=1.13u l=150n m=2
    mp2 (net123 B0 VDD VDD) pfet_01v8_hvt w=(620n) l=150n m=(1)*(1)
    mp4 (Y C0 VDD VDD) pfet_01v8_hvt w=(620n) l=150n m=(1)*(1)
ends OAI221X1_LP

// sky130_scl_9T_LP/OAI21X2_LP/schematic
subckt OAI21X2_LP A0 A1 B0 VDD VSS Y
    mn2 (Y B0 n0 VSS) nfet_01v8 w=(840n) l=150n m=(1)*(1)
    mn1 (n0 A1 VSS VSS) nfet_01v8 w=(840n) l=150n m=(1)*(1)
    mn0 (n0 A0 VSS VSS) nfet_01v8 w=(840n) l=150n m=(1)*(1)
    mp0 (n1 A0 VDD VDD) pfet_01v8_hvt w=(1.24u) l=150n m=(1)*(1)
    mp2 (Y B0 VDD VDD) pfet_01v8_hvt w=(1.24u) l=150n m=(1)*(1)
    mp1 (Y A1 n1 VDD) pfet_01v8_hvt w=1.13u l=150n m=1
ends OAI21X2_LP

// sky130_scl_9T_LP/OAI21X1_LP/schematic
subckt OAI21X1_LP A0 A1 B0 VDD VSS Y
    mn2 (Y B0 n0 VSS) nfet_01v8 w=(420n) l=150n m=(1)*(1)
    mn1 (n0 A1 VSS VSS) nfet_01v8 w=(420n) l=150n m=(1)*(1)
    mn0 (n0 A0 VSS VSS) nfet_01v8 w=(420n) l=150n m=(1)*(1)
    mp0 (n1 A0 VDD VDD) pfet_01v8_hvt w=(620n) l=150n m=(1)*(1)
    mp2 (Y B0 VDD VDD) pfet_01v8_hvt w=(620n) l=150n m=(1)*(1)
    mp1 (Y A1 n1 VDD) pfet_01v8_hvt w=1.13u l=150n m=4
ends OAI21X1_LP

// sky130_scl_9T_LP/OAI211X2_LP/schematic
subckt OAI211X2_LP A0 A1 B0 C0 VDD VSS Y
    mn1 (n0 A1 VSS VSS) nfet_01v8 w=(840n) l=150n m=(1)*(1)
    mn0 (n0 A0 VSS VSS) nfet_01v8 w=(840n) l=150n m=(1)*(1)
    mn2 (n1 B0 n0 VSS) nfet_01v8 w=(840n) l=150n m=(1)*(1)
    mn3 (Y C0 n1 VSS) nfet_01v8 w=(840n) l=150n m=(1)*(1)
    mp1 (Y A1 n2 VDD) pfet_01v8_hvt w=1.13u l=150n m=1
    mp0 (n2 A0 VDD VDD) pfet_01v8_hvt w=(1.24u) l=150n m=(1)*(1)
    mp3 (Y C0 VDD VDD) pfet_01v8_hvt w=(1.24u) l=150n m=(1)*(1)
    mp2 (Y B0 VDD VDD) pfet_01v8_hvt w=(1.24u) l=150n m=(1)*(1)
ends OAI211X2_LP

// sky130_scl_9T_LP/OAI211X1_LP/schematic
subckt OAI211X1_LP A0 A1 B0 C0 VDD VSS Y
    mn1 (n0 A1 VSS VSS) nfet_01v8 w=(420n) l=150n m=(1)*(1)
    mn0 (n0 A0 VSS VSS) nfet_01v8 w=(420n) l=150n m=(1)*(1)
    mn2 (n1 B0 n0 VSS) nfet_01v8 w=(420n) l=150n m=(1)*(1)
    mn3 (Y C0 n1 VSS) nfet_01v8 w=(420n) l=150n m=(1)*(1)
    mp1 (Y A1 n2 VDD) pfet_01v8_hvt w=625n l=150n m=1
    mp0 (n2 A0 VDD VDD) pfet_01v8_hvt w=(620n) l=150n m=(1)*(1)
    mp3 (Y C0 VDD VDD) pfet_01v8_hvt w=(620n) l=150n m=(1)*(1)
    mp2 (Y B0 VDD VDD) pfet_01v8_hvt w=(620n) l=150n m=(1)*(1)
ends OAI211X1_LP

// sky130_scl_9T_LP/NOR4X4_LP/schematic
subckt NOR4X4_LP A B C D VDD VSS Y
    mn2 (Y C VSS VSS) nfet_01v8 w=(840n) l=150n m=(1)*(2)
    mn3 (Y D VSS VSS) nfet_01v8 w=(840n) l=150n m=(1)*(2)
    mn0 (Y A VSS VSS) nfet_01v8 w=(840n) l=150n m=(1)*(2)
    mn1 (Y B VSS VSS) nfet_01v8 w=(840n) l=150n m=(1)*(2)
    mp1 (n1 B n0 VDD) pfet_01v8_hvt w=(1.24u) l=150n m=(1)*(2)
    mp3 (Y D n2 VDD) pfet_01v8_hvt w=1.13u l=150n m=1
    mp2 (n2 C n1 VDD) pfet_01v8_hvt w=(1.24u) l=150n m=(1)*(2)
    mp0 (n0 A VDD VDD) pfet_01v8_hvt w=(1.24u) l=150n m=(1)*(2)
ends NOR4X4_LP

// sky130_scl_9T_LP/NOR4X2_LP/schematic
subckt NOR4X2_LP A B C D VDD VSS Y
    mn2 (Y C VSS VSS) nfet_01v8 w=(840n) l=150n m=(1)*(1)
    mn3 (Y D VSS VSS) nfet_01v8 w=(840n) l=150n m=(1)*(1)
    mn0 (Y A VSS VSS) nfet_01v8 w=(840n) l=150n m=(1)*(1)
    mn1 (Y B VSS VSS) nfet_01v8 w=(840n) l=150n m=(1)*(1)
    mp1 (n1 B n0 VDD) pfet_01v8_hvt w=(1.24u) l=150n m=(1)*(1)
    mp3 (Y D n2 VDD) pfet_01v8_hvt w=1.13u l=150n m=1
    mp2 (n2 C n1 VDD) pfet_01v8_hvt w=(1.24u) l=150n m=(1)*(1)
    mp0 (n0 A VDD VDD) pfet_01v8_hvt w=(1.24u) l=150n m=(1)*(1)
ends NOR4X2_LP

// sky130_scl_9T_LP/NOR4X1_LP/schematic
subckt NOR4X1_LP A B C D VDD VSS Y
    mn2 (Y C VSS VSS) nfet_01v8 w=(420n) l=150n m=(1)*(1)
    mn3 (Y D VSS VSS) nfet_01v8 w=(420n) l=150n m=(1)*(1)
    mn0 (Y A VSS VSS) nfet_01v8 w=(420n) l=150n m=(1)*(1)
    mn1 (Y B VSS VSS) nfet_01v8 w=(420n) l=150n m=(1)*(1)
    mp1 (n1 B n0 VDD) pfet_01v8_hvt w=(620n) l=150n m=(1)*(1)
    mp3 (Y D n2 VDD) pfet_01v8_hvt w=1.13u l=150n m=1
    mp2 (n2 C n1 VDD) pfet_01v8_hvt w=(620n) l=150n m=(1)*(1)
    mp0 (n0 A VDD VDD) pfet_01v8_hvt w=(620n) l=150n m=(1)*(1)
ends NOR4X1_LP

// sky130_scl_9T_LP/NOR3X4_LP/schematic
subckt NOR3X4_LP A B C VDD VSS Y
    mn0 (Y A VSS VSS) nfet_01v8 w=(840n) l=150n m=(1)*(2)
    mn1 (Y B VSS VSS) nfet_01v8 w=(840n) l=150n m=(1)*(2)
    mn2 (Y C VSS VSS) nfet_01v8 w=(840n) l=150n m=(1)*(2)
    mp1 (n1 B n0 VDD) pfet_01v8_hvt w=(1.24u) l=150n m=(1)*(2)
    mp2 (Y C n1 VDD) pfet_01v8_hvt w=1.13u l=150n m=1
    mp0 (n0 A VDD VDD) pfet_01v8_hvt w=(1.24u) l=150n m=(1)*(2)
ends NOR3X4_LP

// sky130_scl_9T_LP/NOR3X2_LP/schematic
subckt NOR3X2_LP A B C VDD VSS Y
    mn0 (Y A VSS VSS) nfet_01v8 w=(840n) l=150n m=(1)*(1)
    mn1 (Y B VSS VSS) nfet_01v8 w=(840n) l=150n m=(1)*(1)
    mn2 (Y C VSS VSS) nfet_01v8 w=(840n) l=150n m=(1)*(1)
    mp1 (n1 B n0 VDD) pfet_01v8_hvt w=(1.24u) l=150n m=(1)*(1)
    mp2 (Y C n1 VDD) pfet_01v8_hvt w=1.13u l=150n m=1
    mp0 (n0 A VDD VDD) pfet_01v8_hvt w=(1.24u) l=150n m=(1)*(1)
ends NOR3X2_LP

// sky130_scl_9T_LP/NOR3X1_LP/schematic
subckt NOR3X1_LP A B C VDD VSS Y
    mn0 (Y A VSS VSS) nfet_01v8 w=(420n) l=150n m=(1)*(1)
    mn1 (Y B VSS VSS) nfet_01v8 w=(420n) l=150n m=(1)*(1)
    mn2 (Y C VSS VSS) nfet_01v8 w=(420n) l=150n m=(1)*(1)
    mp1 (n1 B n0 VDD) pfet_01v8_hvt w=(620n) l=150n m=(1)*(1)
    mp2 (Y C n1 VDD) pfet_01v8_hvt w=1.13u l=150n m=2
    mp0 (n0 A VDD VDD) pfet_01v8_hvt w=(620n) l=150n m=(1)*(1)
ends NOR3X1_LP

// sky130_scl_9T_LP/NOR2X4_LP/schematic
subckt NOR2X4_LP A B VDD VSS Y
    mn1 (Y B VSS VSS) nfet_01v8 w=(840n) l=150n m=(1)*(2)
    mn0 (Y A VSS VSS) nfet_01v8 w=(840n) l=150n m=(1)*(2)
    mp1 (Y B net41 VDD) pfet_01v8_hvt w=1.13u l=150n m=1
    mp0 (net41 A VDD VDD) pfet_01v8_hvt w=(1.24u) l=150n m=(1)*(2)
ends NOR2X4_LP

// sky130_scl_9T_LP/NOR2X2_LP/schematic
subckt NOR2X2_LP A B VDD VSS Y
    mn1 (Y B VSS VSS) nfet_01v8 w=(840n) l=150n m=(1)*(1)
    mn0 (Y A VSS VSS) nfet_01v8 w=(840n) l=150n m=(1)*(1)
    mp1 (Y B net41 VDD) pfet_01v8_hvt w=1.13u l=150n m=1
    mp0 (net41 A VDD VDD) pfet_01v8_hvt w=(1.24u) l=150n m=(1)*(1)
ends NOR2X2_LP

// sky130_scl_9T_LP/NOR2X1_LP/schematic
subckt NOR2X1_LP A B VDD VSS Y
    mn1 (Y B VSS VSS) nfet_01v8 w=(420n) l=150n m=(1)*(1)
    mn0 (Y A VSS VSS) nfet_01v8 w=(420n) l=150n m=(1)*(1)
    mp1 (Y B net41 VDD) pfet_01v8_hvt w=1.13u l=150n m=1
    mp0 (net41 A VDD VDD) pfet_01v8_hvt w=(620n) l=150n m=(1)*(1)
ends NOR2X1_LP

// sky130_scl_9T_LP/NAND4X4_LP/schematic
subckt NAND4X4_LP A B C D VDD VSS Y
    mn1 (n1 B n2 VSS) nfet_01v8 w=(840n) l=150n m=(1)*(2)
    mn3 (Y D n0 VSS) nfet_01v8 w=(840n) l=150n m=(1)*(2)
    mn2 (n0 C n1 VSS) nfet_01v8 w=(840n) l=150n m=(1)*(2)
    mn0 (n2 A VSS VSS) nfet_01v8 w=(840n) l=150n m=(1)*(2)
    mp3 (Y D VDD VDD) pfet_01v8_hvt w=(1.24u) l=150n m=(1)*(2)
    mp2 (Y C VDD VDD) pfet_01v8_hvt w=(1.24u) l=150n m=(1)*(2)
    mp1 (Y B VDD VDD) pfet_01v8_hvt w=(1.24u) l=150n m=(1)*(2)
    mp0 (Y A VDD VDD) pfet_01v8_hvt w=1.13u l=150n m=1
ends NAND4X4_LP

// sky130_scl_9T_LP/NAND4X2_LP/schematic
subckt NAND4X2_LP A B C D VDD VSS Y
    mn1 (n1 B n2 VSS) nfet_01v8 w=(840n) l=150n m=(1)*(1)
    mn3 (Y D n0 VSS) nfet_01v8 w=(840n) l=150n m=(1)*(1)
    mn2 (n0 C n1 VSS) nfet_01v8 w=(840n) l=150n m=(1)*(1)
    mn0 (n2 A VSS VSS) nfet_01v8 w=(840n) l=150n m=(1)*(1)
    mp3 (Y D VDD VDD) pfet_01v8_hvt w=(1.24u) l=150n m=(1)*(1)
    mp2 (Y C VDD VDD) pfet_01v8_hvt w=(1.24u) l=150n m=(1)*(1)
    mp1 (Y B VDD VDD) pfet_01v8_hvt w=(1.24u) l=150n m=(1)*(1)
    mp0 (Y A VDD VDD) pfet_01v8_hvt w=1.13u l=150n m=1
ends NAND4X2_LP

// sky130_scl_9T_LP/NAND4X1_LP/schematic
subckt NAND4X1_LP A B C D VDD VSS Y
    mn1 (n1 B n2 VSS) nfet_01v8 w=(420n) l=150n m=(1)*(1)
    mn3 (Y D n0 VSS) nfet_01v8 w=(420n) l=150n m=(1)*(1)
    mn2 (n0 C n1 VSS) nfet_01v8 w=(420n) l=150n m=(1)*(1)
    mn0 (n2 A VSS VSS) nfet_01v8 w=(420n) l=150n m=(1)*(1)
    mp3 (Y D VDD VDD) pfet_01v8_hvt w=(620n) l=150n m=(1)*(1)
    mp2 (Y C VDD VDD) pfet_01v8_hvt w=(620n) l=150n m=(1)*(1)
    mp1 (Y B VDD VDD) pfet_01v8_hvt w=(620n) l=150n m=(1)*(1)
    mp0 (Y A VDD VDD) pfet_01v8_hvt w=1.13u l=150n m=2
ends NAND4X1_LP

// sky130_scl_9T_LP/NAND3X4_LP/schematic
subckt NAND3X4_LP A B C VDD VSS Y
    mn1 (n0 B n1 VSS) nfet_01v8 w=(840n) l=150n m=(1)*(2)
    mn2 (Y C n0 VSS) nfet_01v8 w=(840n) l=150n m=(1)*(2)
    mn0 (n1 A VSS VSS) nfet_01v8 w=(840n) l=150n m=(1)*(2)
    mp0 (Y A VDD VDD) pfet_01v8_hvt w=(1.24u) l=150n m=(1)*(2)
    mp1 (Y B VDD VDD) pfet_01v8_hvt w=(1.24u) l=150n m=(1)*(2)
    mp2 (Y C VDD VDD) pfet_01v8_hvt w=1.13u l=150n m=1
ends NAND3X4_LP

// sky130_scl_9T_LP/NAND3X2_LP/schematic
subckt NAND3X2_LP A B C VDD VSS Y
    mn1 (n0 B n1 VSS) nfet_01v8 w=(840n) l=150n m=(1)*(1)
    mn2 (Y C n0 VSS) nfet_01v8 w=(840n) l=150n m=(1)*(1)
    mn0 (n1 A VSS VSS) nfet_01v8 w=(840n) l=150n m=(1)*(1)
    mp0 (Y A VDD VDD) pfet_01v8_hvt w=(1.24u) l=150n m=(1)*(1)
    mp1 (Y B VDD VDD) pfet_01v8_hvt w=(1.24u) l=150n m=(1)*(1)
    mp2 (Y C VDD VDD) pfet_01v8_hvt w=1.13u l=150n m=1
ends NAND3X2_LP

// sky130_scl_9T_LP/NAND3X1_LP/schematic
subckt NAND3X1_LP A B C VDD VSS Y
    mn1 (n0 B n1 VSS) nfet_01v8 w=(420n) l=150n m=(1)*(1)
    mn2 (Y C n0 VSS) nfet_01v8 w=(420n) l=150n m=(1)*(1)
    mn0 (n1 A VSS VSS) nfet_01v8 w=(420n) l=150n m=(1)*(1)
    mp0 (Y A VDD VDD) pfet_01v8_hvt w=(620n) l=150n m=(1)*(1)
    mp1 (Y B VDD VDD) pfet_01v8_hvt w=(620n) l=150n m=(1)*(1)
    mp2 (Y C VDD VDD) pfet_01v8_hvt w=1.13u l=150n m=2
ends NAND3X1_LP

// sky130_scl_9T_LP/NAND2X4_LP/schematic
subckt NAND2X4_LP A B VDD VSS Y
    mn1 (Y B n0 VSS) nfet_01v8 w=(840n) l=150n m=(1)*(2)
    mn0 (n0 A VSS VSS) nfet_01v8 w=(840n) l=150n m=(1)*(2)
    mp1 (Y B VDD VDD) pfet_01v8_hvt w=(1.24u) l=150n m=(1)*(2)
    mp0 (Y A VDD VDD) pfet_01v8_hvt w=1.13u l=150n m=1
ends NAND2X4_LP

// sky130_scl_9T_LP/NAND2X2_LP/schematic
subckt NAND2X2_LP A B VDD VSS Y
    mn1 (Y B n0 VSS) nfet_01v8 w=(840n) l=150n m=(1)*(1)
    mn0 (n0 A VSS VSS) nfet_01v8 w=(840n) l=150n m=(1)*(1)
    mp1 (Y B VDD VDD) pfet_01v8_hvt w=1.13u l=150n m=1
    mp0 (Y A VDD VDD) pfet_01v8_hvt w=(1.24u) l=150n m=(1)*(1)
ends NAND2X2_LP

// sky130_scl_9T_LP/NAND2X1_LP/schematic
subckt NAND2X1_LP A B VDD VSS Y
    mn1 (Y B n0 VSS) nfet_01v8 w=(420n) l=150n m=(1)*(1)
    mn0 (n0 A VSS VSS) nfet_01v8 w=(420n) l=150n m=(1)*(1)
    mp1 (Y B VDD VDD) pfet_01v8_hvt w=(620n) l=150n m=(1)*(1)
    mp0 (Y A VDD VDD) pfet_01v8_hvt w=1.13u l=150n m=1
ends NAND2X1_LP

// sky130_scl_9T_LP/MX4X4_LP/schematic
subckt MX4X4_LP A B C D S0 S1 VDD VSS Y
    mn9 (n1 S0 n9 VSS) nfet_01v8 w=(420n) l=150n m=(1)*(1)
    mn6 (n7 C VSS VSS) nfet_01v8 w=(420n) l=150n m=(1)*(1)
    mn7 (n1 S0b n7 VSS) nfet_01v8 w=(420n) l=150n m=(1)*(1)
    mn4 (n5 B VSS VSS) nfet_01v8 w=(420n) l=150n m=(1)*(1)
    mn5 (n0 S0 n5 VSS) nfet_01v8 w=(420n) l=150n m=(1)*(1)
    mn3 (n0 S0b n3 VSS) nfet_01v8 w=(420n) l=150n m=(1)*(1)
    mn2 (n3 A VSS VSS) nfet_01v8 w=(420n) l=150n m=(1)*(1)
    mn12 (Y n2 VSS VSS) nfet_01v8 w=(840n) l=150n m=(1)*(2)
    mn1 (S1b S1 VSS VSS) nfet_01v8 w=(420n) l=150n m=(1)*(1)
    mn11 (n2 S1 n1 VSS) nfet_01v8 w=(420n) l=150n m=(1)*(1)
    mn8 (n9 D VSS VSS) nfet_01v8 w=(420n) l=150n m=(1)*(1)
    mn10 (n2 S1b n0 VSS) nfet_01v8 w=(420n) l=150n m=(1)*(1)
    mn0 (S0b S0 VSS VSS) nfet_01v8 w=(420n) l=150n m=(1)*(1)
    mp9 (n1 S0b n10 VDD) pfet_01v8_hvt w=(540n) l=150n m=(1)*(1)
    mp8 (n10 D VDD VDD) pfet_01v8_hvt w=(540n) l=150n m=(1)*(1)
    mp7 (n1 S0 n8 VDD) pfet_01v8_hvt w=(540n) l=150n m=(1)*(1)
    mp6 (n8 C VDD VDD) pfet_01v8_hvt w=(540n) l=150n m=(1)*(1)
    mp5 (n0 S0b n6 VDD) pfet_01v8_hvt w=(540n) l=150n m=(1)*(1)
    mp4 (n6 B VDD VDD) pfet_01v8_hvt w=(540n) l=150n m=(1)*(1)
    mp3 (n0 S0 n4 VDD) pfet_01v8_hvt w=625n l=150n m=1
    mp2 (n4 A VDD VDD) pfet_01v8_hvt w=(540n) l=150n m=(1)*(1)
    mp12 (Y n2 VDD VDD) pfet_01v8_hvt w=625n l=150n m=1
    mp0 (S0b S0 VDD VDD) pfet_01v8_hvt w=(540n) l=150n m=(1)*(1)
    mp10 (n2 S1 n0 VDD) pfet_01v8_hvt w=(620n) l=150n m=(1)*(1)
    mp11 (n1 S1b n2 VDD) pfet_01v8_hvt w=625n l=150n m=1
    mp1 (S1b S1 VDD VDD) pfet_01v8_hvt w=(540n) l=150n m=(1)*(1)
ends MX4X4_LP

// sky130_scl_9T_LP/MX4X1_LP/schematic
subckt MX4X1_LP A B C D S0 S1 VDD VSS Y
    mn9 (n1 S0 n9 VSS) nfet_01v8 w=(420n) l=150n m=(1)*(1)
    mn6 (n7 C VSS VSS) nfet_01v8 w=(420n) l=150n m=(1)*(1)
    mn7 (n1 S0b n7 VSS) nfet_01v8 w=(420n) l=150n m=(1)*(1)
    mn4 (n5 B VSS VSS) nfet_01v8 w=(420n) l=150n m=(1)*(1)
    mn5 (n0 S0 n5 VSS) nfet_01v8 w=(420n) l=150n m=(1)*(1)
    mn3 (n0 S0b n3 VSS) nfet_01v8 w=(420n) l=150n m=(1)*(1)
    mn2 (n3 A VSS VSS) nfet_01v8 w=(420n) l=150n m=(1)*(1)
    mn12 (Y n2 VSS VSS) nfet_01v8 w=(420n) l=150n m=(1)*(1)
    mn1 (S1b S1 VSS VSS) nfet_01v8 w=(420n) l=150n m=(1)*(1)
    mn11 (n2 S1 n1 VSS) nfet_01v8 w=(420n) l=150n m=(1)*(1)
    mn8 (n9 D VSS VSS) nfet_01v8 w=(420n) l=150n m=(1)*(1)
    mn10 (n2 S1b n0 VSS) nfet_01v8 w=(420n) l=150n m=(1)*(1)
    mn0 (S0b S0 VSS VSS) nfet_01v8 w=(420n) l=150n m=(1)*(1)
    mp9 (n1 S0b n10 VDD) pfet_01v8_hvt w=(540n) l=150n m=(1)*(1)
    mp8 (n10 D VDD VDD) pfet_01v8_hvt w=(540n) l=150n m=(1)*(1)
    mp7 (n1 S0 n8 VDD) pfet_01v8_hvt w=(540n) l=150n m=(1)*(1)
    mp6 (n8 C VDD VDD) pfet_01v8_hvt w=(540n) l=150n m=(1)*(1)
    mp5 (n0 S0b n6 VDD) pfet_01v8_hvt w=(540n) l=150n m=(1)*(1)
    mp4 (n6 B VDD VDD) pfet_01v8_hvt w=(540n) l=150n m=(1)*(1)
    mp3 (n0 S0 n4 VDD) pfet_01v8_hvt w=1.13u l=150n m=1
    mp2 (n4 A VDD VDD) pfet_01v8_hvt w=(540n) l=150n m=(1)*(1)
    mp12 (Y n2 VDD VDD) pfet_01v8_hvt w=1.13u l=150n m=1
    mp0 (S0b S0 VDD VDD) pfet_01v8_hvt w=(540n) l=150n m=(1)*(1)
    mp10 (n2 S1 n0 VDD) pfet_01v8_hvt w=(540n) l=150n m=(1)*(1)
    mp11 (n1 S1b n2 VDD) pfet_01v8_hvt w=(540n) l=150n m=(1)*(1)
    mp1 (S1b S1 VDD VDD) pfet_01v8_hvt w=(540n) l=150n m=(1)*(1)
ends MX4X1_LP

// sky130_scl_9T_LP/MX2X4_LP/schematic
subckt MX2X4_LP A B S0 VDD VSS Y
    mn3 (n5 B VSS VSS) nfet_01v8 w=(420n) l=150n m=(1)*(1)
    mn4 (n0 S0 n5 VSS) nfet_01v8 w=(420n) l=150n m=(1)*(1)
    mn0 (S0b S0 VSS VSS) nfet_01v8 w=(420n) l=150n m=(1)*(1)
    mn1 (n3 A VSS VSS) nfet_01v8 w=(420n) l=150n m=(1)*(1)
    mn5 (Y n0 VSS VSS) nfet_01v8 w=(840n) l=150n m=(1)*(2)
    mn2 (n0 S0b n3 VSS) nfet_01v8 w=(420n) l=150n m=(1)*(1)
    mp4 (n0 S0b n6 VDD) pfet_01v8_hvt w=(540n) l=150n m=(1)*(1)
    mp3 (n6 B VDD VDD) pfet_01v8_hvt w=(540n) l=150n m=(1)*(1)
    mp5 (Y n0 VDD VDD) pfet_01v8_hvt w=625n l=150n m=1
    mp0 (S0b S0 VDD VDD) pfet_01v8_hvt w=(540n) l=150n m=(1)*(1)
    mp2 (n0 S0 n4 VDD) pfet_01v8_hvt w=625n l=150n m=1
    mp1 (n4 A VDD VDD) pfet_01v8_hvt w=(540n) l=150n m=(1)*(1)
ends MX2X4_LP

// sky130_scl_9T_LP/MX2X1_LP/schematic
subckt MX2X1_LP A B S0 VDD VSS Y
    mn3 (n5 B VSS VSS) nfet_01v8 w=(420n) l=150n m=(1)*(1)
    mn4 (n0 S0 n5 VSS) nfet_01v8 w=(420n) l=150n m=(1)*(1)
    mn0 (S0b S0 VSS VSS) nfet_01v8 w=(420n) l=150n m=(1)*(1)
    mn1 (n3 A VSS VSS) nfet_01v8 w=(420n) l=150n m=(1)*(1)
    mn5 (Y n0 VSS VSS) nfet_01v8 w=(420n) l=150n m=(1)*(1)
    mn2 (n0 S0b n3 VSS) nfet_01v8 w=(420n) l=150n m=(1)*(1)
    mp4 (n0 S0b n6 VDD) pfet_01v8_hvt w=(540n) l=150n m=(1)*(1)
    mp3 (n6 B VDD VDD) pfet_01v8_hvt w=(540n) l=150n m=(1)*(1)
    mp5 (Y n0 VDD VDD) pfet_01v8_hvt w=1.13u l=150n m=1
    mp0 (S0b S0 VDD VDD) pfet_01v8_hvt w=(540n) l=150n m=(1)*(1)
    mp2 (n0 S0 n4 VDD) pfet_01v8_hvt w=1.13u l=150n m=1
    mp1 (n4 A VDD VDD) pfet_01v8_hvt w=(540n) l=150n m=(1)*(1)
ends MX2X1_LP

// sky130_scl_9T_LP/INVX8_LP/schematic
subckt INVX8_LP A VDD VSS Y
    mn0 (Y A VSS VSS) nfet_01v8 w=(840n) l=150n m=(1)*(4)
    mp0 (Y A VDD VDD) pfet_01v8_hvt w=1.13u l=150n m=2
ends INVX8_LP

// sky130_scl_9T_LP/INVX4_LP/schematic
subckt INVX4_LP A VDD VSS Y
    mn0 (Y A VSS VSS) nfet_01v8 w=(840n) l=150n m=(1)*(2)
    mp0 (Y A VDD VDD) pfet_01v8_hvt w=(1.24u) l=150n m=(1)*(2)
ends INVX4_LP

// sky130_scl_9T_LP/INVX2_LP/schematic
subckt INVX2_LP A VDD VSS Y
    mn0 (Y A VSS VSS) nfet_01v8 w=(420n) l=150n m=(1)*(2)
    mp0 (Y A VDD VDD) pfet_01v8_hvt w=(620n) l=150n m=(1)*(2)
ends INVX2_LP

// sky130_scl_9T_LP/INVX1_LP/schematic
subckt INVX1_LP A VDD VSS Y
    mn0 (Y A VSS VSS) nfet_01v8 w=760n l=150n m=1
    mp0 (Y A VDD VDD) pfet_01v8_hvt w=(620n) l=150n m=(1)*(1)
ends INVX1_LP

// sky130_scl_9T_LP/INVX16_LP/schematic
subckt INVX16_LP A VDD VSS Y
    mn0 (Y A VSS VSS) nfet_01v8 w=(840n) l=150n m=(1)*(8)
    mp0 (Y A VDD VDD) pfet_01v8_hvt w=1.13u l=150n m=2
ends INVX16_LP

// sky130_scl_9T_LP/DLY4X4_LP/schematic
subckt DLY4X4_LP A VDD VSS Y
    mn14 (net345 VDD net341 VSS) nfet_01v8 w=(420n) l=150n m=(1)*(1)
    mn13 (net341 net353 VSS VSS) nfet_01v8 w=(420n) l=150n m=(1)*(1)
    mn12 (net353 VDD net349 VSS) nfet_01v8 w=(420n) l=150n m=(1)*(1)
    mn11 (net349 net361 VSS VSS) nfet_01v8 w=(420n) l=150n m=(1)*(1)
    mn10 (net361 VDD net357 VSS) nfet_01v8 w=(420n) l=150n m=(1)*(1)
    mn9 (net357 net369 VSS VSS) nfet_01v8 w=(420n) l=150n m=(1)*(1)
    mn15 (net333 net345 VSS VSS) nfet_01v8 w=(420n) l=150n m=(1)*(1)
    mn6 (net377 VDD net373 VSS) nfet_01v8 w=(420n) l=150n m=(1)*(1)
    mn0 (net397 A VSS VSS) nfet_01v8 w=(420n) l=150n m=(1)*(1)
    mn4 (net385 VDD net381 VSS) nfet_01v8 w=(420n) l=150n m=(1)*(1)
    mn1 (net389 net397 VSS VSS) nfet_01v8 w=(420n) l=150n m=(1)*(1)
    mn7 (net365 net377 VSS VSS) nfet_01v8 w=(420n) l=150n m=(1)*(1)
    mn16 (Y net333 VSS VSS) nfet_01v8 w=(420n) l=150n m=(1)*(4)
    mn3 (net381 net393 VSS VSS) nfet_01v8 w=(420n) l=150n m=(1)*(1)
    mn2 (net393 VDD net389 VSS) nfet_01v8 w=(420n) l=150n m=(1)*(1)
    mn8 (net369 VDD net365 VSS) nfet_01v8 w=(420n) l=150n m=(1)*(1)
    mn5 (net373 net385 VSS VSS) nfet_01v8 w=(420n) l=150n m=(1)*(1)
    mp8 (net369 VSS net300 VDD) pfet_01v8_hvt w=(540n) l=150n m=(1)*(1)
    mp7 (net300 net377 VDD VDD) pfet_01v8_hvt w=(540n) l=150n m=(1)*(1)
    mp9 (net292 net369 VDD VDD) pfet_01v8_hvt w=(540n) l=150n m=(1)*(1)
    mp10 (net361 VSS net292 VDD) pfet_01v8_hvt w=(540n) l=150n m=(1)*(1)
    mp6 (net377 VSS net308 VDD) pfet_01v8_hvt w=(540n) l=150n m=(1)*(1)
    mp5 (net308 net385 VDD VDD) pfet_01v8_hvt w=(540n) l=150n m=(1)*(1)
    mp4 (net385 VSS net316 VDD) pfet_01v8_hvt w=(540n) l=150n m=(1)*(1)
    mp3 (net316 net393 VDD VDD) pfet_01v8_hvt w=(540n) l=150n m=(1)*(1)
    mp2 (net393 VSS net324 VDD) pfet_01v8_hvt w=(540n) l=150n m=(1)*(1)
    mp1 (net324 net397 VDD VDD) pfet_01v8_hvt w=(540n) l=150n m=(1)*(1)
    mp11 (net284 net361 VDD VDD) pfet_01v8_hvt w=(540n) l=150n m=(1)*(1)
    mp12 (net353 VSS net284 VDD) pfet_01v8_hvt w=(540n) l=150n m=(1)*(1)
    mp13 (net276 net353 VDD VDD) pfet_01v8_hvt w=(540n) l=150n m=(1)*(1)
    mp14 (net345 VSS net276 VDD) pfet_01v8_hvt w=(540n) l=150n m=(1)*(1)
    mp15 (net333 net345 VDD VDD) pfet_01v8_hvt w=(620n) l=150n m=(1)*(1)
    mp0 (net397 A VDD VDD) pfet_01v8_hvt w=(540n) l=150n m=(1)*(1)
    mp16 (Y net333 VDD VDD) pfet_01v8_hvt w=(620n) l=150n m=(1)*(4)
ends DLY4X4_LP

// sky130_scl_9T_LP/DLY2X4_LP/schematic
subckt DLY2X4_LP A VDD VSS Y
    mn6 (n3 VDD n10 VSS) nfet_01v8 w=(420n) l=150n m=(1)*(1)
    mn5 (n10 n2 VSS VSS) nfet_01v8 w=(420n) l=150n m=(1)*(1)
    mn8 (Y n4 VSS VSS) nfet_01v8 w=(420n) l=150n m=(1)*(4)
    mn4 (n2 VDD n8 VSS) nfet_01v8 w=(420n) l=150n m=(1)*(1)
    mn3 (n8 n1 VSS VSS) nfet_01v8 w=(420n) l=150n m=(1)*(1)
    mn2 (n1 VDD n6 VSS) nfet_01v8 w=(420n) l=150n m=(1)*(1)
    mn1 (n6 n0 VSS VSS) nfet_01v8 w=(420n) l=150n m=(1)*(1)
    mn7 (n4 n3 VSS VSS) nfet_01v8 w=(420n) l=150n m=(1)*(1)
    mn0 (n0 A VSS VSS) nfet_01v8 w=(420n) l=150n m=(1)*(1)
    mp6 (n3 VSS n11 VDD) pfet_01v8_hvt w=(540n) l=150n m=(1)*(1)
    mp5 (n11 n2 VDD VDD) pfet_01v8_hvt w=(540n) l=150n m=(1)*(1)
    mp8 (Y n4 VDD VDD) pfet_01v8_hvt w=1.13u l=150n m=1
    mp4 (n2 VSS n9 VDD) pfet_01v8_hvt w=(540n) l=150n m=(1)*(1)
    mp3 (n9 n1 VDD VDD) pfet_01v8_hvt w=(540n) l=150n m=(1)*(1)
    mp2 (n1 VSS n7 VDD) pfet_01v8_hvt w=1.13u l=150n m=1
    mp1 (n7 n0 VDD VDD) pfet_01v8_hvt w=(540n) l=150n m=(1)*(1)
    mp7 (n4 n3 VDD VDD) pfet_01v8_hvt w=1.13u l=150n m=1
    mp0 (n0 A VDD VDD) pfet_01v8_hvt w=(540n) l=150n m=(1)*(1)
ends DLY2X4_LP

// sky130_scl_9T_LP/DLY1X4_LP/schematic
subckt DLY1X4_LP A VDD VSS Y
    mn2 (n1 VDD n4 VSS) nfet_01v8 w=(420n) l=150n m=(1)*(1)
    mn1 (n4 n0 VSS VSS) nfet_01v8 w=(420n) l=150n m=(1)*(1)
    mn4 (Y n2 VSS VSS) nfet_01v8 w=(420n) l=150n m=(1)*(4)
    mn0 (n0 A VSS VSS) nfet_01v8 w=(420n) l=150n m=(1)*(1)
    mn3 (n2 n1 VSS VSS) nfet_01v8 w=(420n) l=150n m=(1)*(1)
    mp2 (n1 VSS n5 VDD) pfet_01v8_hvt w=625n l=150n m=1
    mp1 (n5 n0 VDD VDD) pfet_01v8_hvt w=(540n) l=150n m=(1)*(1)
    mp4 (Y n2 VDD VDD) pfet_01v8_hvt w=625n l=150n m=1
    mp0 (n0 A VDD VDD) pfet_01v8_hvt w=(540n) l=150n m=(1)*(1)
    mp3 (n2 n1 VDD VDD) pfet_01v8_hvt w=625n l=150n m=1
ends DLY1X4_LP

// sky130_scl_9T_LP/DLY1X1_LP/schematic
subckt DLY1X1_LP A VDD VSS Y
    mn2 (n1 VDD n4 VSS) nfet_01v8 w=(420n) l=150n m=(1)*(1)
    mn1 (n4 n0 VSS VSS) nfet_01v8 w=(420n) l=150n m=(1)*(1)
    mn4 (Y n2 VSS VSS) nfet_01v8 w=(420n) l=150n m=(1)*(1)
    mn0 (n0 A VSS VSS) nfet_01v8 w=(420n) l=150n m=(1)*(1)
    mn3 (n2 n1 VSS VSS) nfet_01v8 w=(420n) l=150n m=(1)*(1)
    mp2 (n1 VSS n5 VDD) pfet_01v8_hvt w=1.13u l=150n m=1
    mp1 (n5 n0 VDD VDD) pfet_01v8_hvt w=(540n) l=150n m=(1)*(1)
    mp4 (Y n2 VDD VDD) pfet_01v8_hvt w=1.13u l=150n m=1
    mp0 (n0 A VDD VDD) pfet_01v8_hvt w=(540n) l=150n m=(1)*(1)
    mp3 (n2 n1 VDD VDD) pfet_01v8_hvt w=(540n) l=150n m=(1)*(1)
ends DLY1X1_LP

// sky130_scl_9T_LP/DFFX4_LP/schematic
subckt DFFX4_LP CK D Q QN VDD VSS
    mn26 (n20 CKb n21 VSS) nfet_01v8 w=(420n) l=150n m=(1)*(1)
    mn25 (n21 D VSS VSS) nfet_01v8 w=(420n) l=150n m=(1)*(1)
    mn57 (QN qint VSS VSS) nfet_01v8 w=(420n) l=150n m=(1)*(4)
    mn55 (Q qbint VSS VSS) nfet_01v8 w=(420n) l=150n m=(1)*(4)
    mn50 (n35 qbint VSS VSS) nfet_01v8 w=(420n) l=150n m=(1)*(1)
    mn51 (n30 CKb n35 VSS) nfet_01v8 w=(420n) l=150n m=(1)*(1)
    mn35 (n25 mout VSS VSS) nfet_01v8 w=(420n) l=150n m=(1)*(1)
    mn36 (n20 CKbb n25 VSS) nfet_01v8 w=(420n) l=150n m=(1)*(1)
    mn20 (CKb CK VSS VSS) nfet_01v8 w=(420n) l=150n m=(1)*(1)
    mn45 (qbint n30 VSS VSS) nfet_01v8 w=(420n) l=150n m=(1)*(2)
    mn56 (qint qbint VSS VSS) nfet_01v8 w=(420n) l=150n m=(1)*(1)
    mn21 (CKbb CKb VSS VSS) nfet_01v8 w=(420n) l=150n m=(1)*(1)
    mn30 (mout n20 VSS VSS) nfet_01v8 w=(420n) l=150n m=(1)*(1)
    mn40 (n30 CKbb mout VSS) nfet_01v8 w=(420n) l=150n m=(1)*(1)
    mp26 (n20 CKbb n22 VDD) pfet_01v8_hvt w=(540n) l=150n m=(1)*(1)
    mp25 (n22 D VDD VDD) pfet_01v8_hvt w=(540n) l=150n m=(1)*(1)
    mp51 (n30 CKbb n36 VDD) pfet_01v8_hvt w=1.13u l=150n m=1
    mp50 (n36 qbint VDD VDD) pfet_01v8_hvt w=(540n) l=150n m=(1)*(1)
    mp57 (QN qint VDD VDD) pfet_01v8_hvt w=(620n) l=150n m=(1)*(4)
    mp55 (Q qbint VDD VDD) pfet_01v8_hvt w=1.13u l=150n m=1
    mp35 (n26 mout VDD VDD) pfet_01v8_hvt w=(540n) l=150n m=(1)*(1)
    mp36 (n20 CKb n26 VDD) pfet_01v8_hvt w=1.13u l=150n m=1
    mp20 (CKb CK VDD VDD) pfet_01v8_hvt w=(540n) l=150n m=(1)*(1)
    mp45 (qbint n30 VDD VDD) pfet_01v8_hvt w=1.13u l=150n m=1
    mp56 (qint qbint VDD VDD) pfet_01v8_hvt w=1.13u l=150n m=1
    mp21 (CKbb CKb VDD VDD) pfet_01v8_hvt w=(540n) l=150n m=(1)*(1)
    mp40 (n30 CKb mout VDD) pfet_01v8_hvt w=(540n) l=150n m=(1)*(1)
    mp30 (mout n20 VDD VDD) pfet_01v8_hvt w=(540n) l=150n m=(1)*(1)
ends DFFX4_LP

// sky130_scl_9T_LP/DFFX1_LP/schematic
subckt DFFX1_LP CK D Q QN VDD VSS
    mn26 (n20 CKb n21 VSS) nfet_01v8 w=(420n) l=150n m=(1)*(1)
    mn25 (n21 D VSS VSS) nfet_01v8 w=(420n) l=150n m=(1)*(1)
    mn57 (QN qint VSS VSS) nfet_01v8 w=(420n) l=150n m=(1)*(1)
    mn55 (Q qbint VSS VSS) nfet_01v8 w=(420n) l=150n m=(1)*(1)
    mn50 (n35 qbint VSS VSS) nfet_01v8 w=(420n) l=150n m=(1)*(1)
    mn51 (n30 CKb n35 VSS) nfet_01v8 w=(420n) l=150n m=(1)*(1)
    mn35 (n25 mout VSS VSS) nfet_01v8 w=(420n) l=150n m=(1)*(1)
    mn36 (n20 CKbb n25 VSS) nfet_01v8 w=(420n) l=150n m=(1)*(1)
    mn20 (CKb CK VSS VSS) nfet_01v8 w=(420n) l=150n m=(1)*(1)
    mn45 (qbint n30 VSS VSS) nfet_01v8 w=(420n) l=150n m=(1)*(1)
    mn56 (qint qbint VSS VSS) nfet_01v8 w=(420n) l=150n m=(1)*(1)
    mn21 (CKbb CKb VSS VSS) nfet_01v8 w=(420n) l=150n m=(1)*(1)
    mn30 (mout n20 VSS VSS) nfet_01v8 w=(420n) l=150n m=(1)*(1)
    mn40 (n30 CKbb mout VSS) nfet_01v8 w=(420n) l=150n m=(1)*(1)
    mp26 (n20 CKbb n22 VDD) pfet_01v8_hvt w=(540n) l=150n m=(1)*(1)
    mp25 (n22 D VDD VDD) pfet_01v8_hvt w=(540n) l=150n m=(1)*(1)
    mp51 (n30 CKbb n36 VDD) pfet_01v8_hvt w=(540n) l=150n m=(1)*(1)
    mp50 (n36 qbint VDD VDD) pfet_01v8_hvt w=(540n) l=150n m=(1)*(1)
    mp57 (QN qint VDD VDD) pfet_01v8_hvt w=(620n) l=150n m=(1)*(1)
    mp55 (Q qbint VDD VDD) pfet_01v8_hvt w=625n l=150n m=1
    mp35 (n26 mout VDD VDD) pfet_01v8_hvt w=(540n) l=150n m=(1)*(1)
    mp36 (n20 CKb n26 VDD) pfet_01v8_hvt w=625n l=150n m=1
    mp20 (CKb CK VDD VDD) pfet_01v8_hvt w=(540n) l=150n m=(1)*(1)
    mp45 (qbint n30 VDD VDD) pfet_01v8_hvt w=(540n) l=150n m=(1)*(1)
    mp56 (qint qbint VDD VDD) pfet_01v8_hvt w=(540n) l=150n m=(1)*(1)
    mp21 (CKbb CKb VDD VDD) pfet_01v8_hvt w=(540n) l=150n m=(1)*(1)
    mp40 (n30 CKb mout VDD) pfet_01v8_hvt w=(540n) l=150n m=(1)*(1)
    mp30 (mout n20 VDD VDD) pfet_01v8_hvt w=(540n) l=150n m=(1)*(1)
ends DFFX1_LP

// sky130_scl_9T_LP/DFFSX4_LP/schematic
subckt DFFSX4_LP CK D Q QN SN VDD VSS
    mn51 (n40 qbint n42 VSS) nfet_01v8 w=(420n) l=150n m=(1)*(1)
    mn52 (n35 CKb n40 VSS) nfet_01v8 w=(420n) l=150n m=(1)*(1)
    mn50 (n42 SN VSS VSS) nfet_01v8 w=(420n) l=150n m=(1)*(1)
    mn26 (n20 CKb n21 VSS) nfet_01v8 w=(420n) l=150n m=(1)*(1)
    mn25 (n21 D VSS VSS) nfet_01v8 w=(420n) l=150n m=(1)*(1)
    mn57 (QN net331 VSS VSS) nfet_01v8 w=(420n) l=150n m=(1)*(4)
    mn55 (Q qbint VSS VSS) nfet_01v8 w=(420n) l=150n m=(1)*(4)
    mn30 (n25 SN VSS VSS) nfet_01v8 w=(420n) l=150n m=(1)*(1)
    mn31 (mout n20 n25 VSS) nfet_01v8 w=(420n) l=150n m=(1)*(1)
    mn35 (n20 CKbb n30 VSS) nfet_01v8 w=(420n) l=150n m=(1)*(1)
    mn36 (n30 mout VSS VSS) nfet_01v8 w=(420n) l=150n m=(1)*(1)
    mn56 (net331 qbint VSS VSS) nfet_01v8 w=(420n) l=150n m=(1)*(1)
    mn20 (CKb CK VSS VSS) nfet_01v8 w=(420n) l=150n m=(1)*(1)
    mn21 (CKbb CKb VSS VSS) nfet_01v8 w=(420n) l=150n m=(1)*(1)
    mn45 (qbint n35 VSS VSS) nfet_01v8 w=(420n) l=150n m=(1)*(2)
    mn40 (n35 CKbb mout VSS) nfet_01v8 w=(420n) l=150n m=(1)*(1)
    mp26 (n20 CKbb n22 VDD) pfet_01v8_hvt w=625n l=150n m=1
    mp25 (n22 D VDD VDD) pfet_01v8_hvt w=(540n) l=150n m=(1)*(1)
    mp57 (QN net331 VDD VDD) pfet_01v8_hvt w=625n l=150n m=1
    mp55 (Q qbint VDD VDD) pfet_01v8_hvt w=(620n) l=150n m=(1)*(4)
    mp36 (n20 CKb n31 VDD) pfet_01v8_hvt w=(540n) l=150n m=(1)*(1)
    mp35 (n31 mout VDD VDD) pfet_01v8_hvt w=(540n) l=150n m=(1)*(1)
    mp20 (CKb CK VDD VDD) pfet_01v8_hvt w=(540n) l=150n m=(1)*(1)
    mp31 (mout n20 VDD VDD) pfet_01v8_hvt w=(540n) l=150n m=(1)*(1)
    mp40 (n35 CKb mout VDD) pfet_01v8_hvt w=(540n) l=150n m=(1)*(1)
    mp56 (net331 qbint VDD VDD) pfet_01v8_hvt w=625n l=150n m=1
    mp45 (qbint n35 VDD VDD) pfet_01v8_hvt w=625n l=150n m=1
    mp52 (n35 CKbb n41 VDD) pfet_01v8_hvt w=(540n) l=150n m=(1)*(1)
    mp21 (CKbb CKb VDD VDD) pfet_01v8_hvt w=(540n) l=150n m=(1)*(1)
    mp30 (mout SN VDD VDD) pfet_01v8_hvt w=(540n) l=150n m=(1)*(1)
    mp51 (n41 qbint VDD VDD) pfet_01v8_hvt w=(540n) l=150n m=(1)*(1)
    mp50 (n41 SN VDD VDD) pfet_01v8_hvt w=(540n) l=150n m=(1)*(1)
ends DFFSX4_LP

// sky130_scl_9T_LP/DFFSX1_LP/schematic
subckt DFFSX1_LP CK D Q QN SN VDD VSS
    mn51 (n40 qbint n42 VSS) nfet_01v8 w=(420n) l=150n m=(1)*(1)
    mn52 (n35 CKb n40 VSS) nfet_01v8 w=(420n) l=150n m=(1)*(1)
    mn50 (n42 SN VSS VSS) nfet_01v8 w=(420n) l=150n m=(1)*(1)
    mn26 (n20 CKb n21 VSS) nfet_01v8 w=(420n) l=150n m=(1)*(1)
    mn25 (n21 D VSS VSS) nfet_01v8 w=(420n) l=150n m=(1)*(1)
    mn57 (QN net331 VSS VSS) nfet_01v8 w=(420n) l=150n m=(1)*(1)
    mn55 (Q qbint VSS VSS) nfet_01v8 w=(420n) l=150n m=(1)*(1)
    mn30 (n25 SN VSS VSS) nfet_01v8 w=(420n) l=150n m=(1)*(1)
    mn31 (mout n20 n25 VSS) nfet_01v8 w=(420n) l=150n m=(1)*(1)
    mn35 (n20 CKbb n30 VSS) nfet_01v8 w=(420n) l=150n m=(1)*(1)
    mn36 (n30 mout VSS VSS) nfet_01v8 w=(420n) l=150n m=(1)*(1)
    mn56 (net331 qbint VSS VSS) nfet_01v8 w=(420n) l=150n m=(1)*(1)
    mn20 (CKb CK VSS VSS) nfet_01v8 w=(420n) l=150n m=(1)*(1)
    mn21 (CKbb CKb VSS VSS) nfet_01v8 w=(420n) l=150n m=(1)*(1)
    mn45 (qbint n35 VSS VSS) nfet_01v8 w=(420n) l=150n m=(1)*(1)
    mn40 (n35 CKbb mout VSS) nfet_01v8 w=(420n) l=150n m=(1)*(1)
    mp26 (n20 CKbb n22 VDD) pfet_01v8_hvt w=1.13u l=150n m=1
    mp25 (n22 D VDD VDD) pfet_01v8_hvt w=(540n) l=150n m=(1)*(1)
    mp57 (QN net331 VDD VDD) pfet_01v8_hvt w=(620n) l=150n m=(1)*(1)
    mp55 (Q qbint VDD VDD) pfet_01v8_hvt w=1.13u l=150n m=1
    mp36 (n20 CKb n31 VDD) pfet_01v8_hvt w=(540n) l=150n m=(1)*(1)
    mp35 (n31 mout VDD VDD) pfet_01v8_hvt w=(540n) l=150n m=(1)*(1)
    mp20 (CKb CK VDD VDD) pfet_01v8_hvt w=(540n) l=150n m=(1)*(1)
    mp31 (mout n20 VDD VDD) pfet_01v8_hvt w=(540n) l=150n m=(1)*(1)
    mp40 (n35 CKb mout VDD) pfet_01v8_hvt w=(540n) l=150n m=(1)*(1)
    mp56 (net331 qbint VDD VDD) pfet_01v8_hvt w=(540n) l=150n m=(1)*(1)
    mp45 (qbint n35 VDD VDD) pfet_01v8_hvt w=(540n) l=150n m=(1)*(1)
    mp52 (n35 CKbb n41 VDD) pfet_01v8_hvt w=(540n) l=150n m=(1)*(1)
    mp21 (CKbb CKb VDD VDD) pfet_01v8_hvt w=(540n) l=150n m=(1)*(1)
    mp30 (mout SN VDD VDD) pfet_01v8_hvt w=(540n) l=150n m=(1)*(1)
    mp51 (n41 qbint VDD VDD) pfet_01v8_hvt w=(540n) l=150n m=(1)*(1)
    mp50 (n41 SN VDD VDD) pfet_01v8_hvt w=(540n) l=150n m=(1)*(1)
ends DFFSX1_LP

// sky130_scl_9T_LP/DFFSRX4_LP/schematic
subckt DFFSRX4_LP CK D Q QN RN SN VDD VSS
    mn26 (n20 CKb n21 VSS) nfet_01v8 w=(420n) l=150n m=(1)*(1)
    mn25 (n21 D VSS VSS) nfet_01v8 w=(420n) l=150n m=(1)*(1)
    mn57 (QN qint VSS VSS) nfet_01v8 w=(420n) l=150n m=(1)*(4)
    mn55 (Q qbint VSS VSS) nfet_01v8 w=(420n) l=150n m=(1)*(4)
    mn35 (n30 mout VSS VSS) nfet_01v8 w=(420n) l=150n m=(1)*(1)
    mn36 (n20 CKbb n30 VSS) nfet_01v8 w=(420n) l=150n m=(1)*(1)
    mn22 (RNb RN VSS VSS) nfet_01v8 w=(420n) l=150n m=(1)*(1)
    mn20 (CKb CK VSS VSS) nfet_01v8 w=(420n) l=150n m=(1)*(1)
    mn45 (qbint n35 VSS VSS) nfet_01v8 w=(420n) l=150n m=(1)*(2)
    mn56 (qint qbint VSS VSS) nfet_01v8 w=(420n) l=150n m=(1)*(1)
    mn52 (n40 qbint n42 VSS) nfet_01v8 w=(420n) l=150n m=(1)*(1)
    mn51 (n40 RNb n42 VSS) nfet_01v8 w=(420n) l=150n m=(1)*(1)
    mn50 (n42 SN VSS VSS) nfet_01v8 w=(420n) l=150n m=(1)*(1)
    mn53 (n35 CKb n40 VSS) nfet_01v8 w=(420n) l=150n m=(1)*(1)
    mn21 (CKbb CKb VSS VSS) nfet_01v8 w=(420n) l=150n m=(1)*(1)
    mn32 (mout n20 net426 VSS) nfet_01v8 w=(420n) l=150n m=(1)*(1)
    mn31 (mout RNb net426 VSS) nfet_01v8 w=(420n) l=150n m=(1)*(1)
    mn40 (n35 CKbb mout VSS) nfet_01v8 w=(420n) l=150n m=(1)*(1)
    mn30 (net426 SN VSS VSS) nfet_01v8 w=(420n) l=150n m=(1)*(1)
    mp26 (n20 CKbb n22 VDD) pfet_01v8_hvt w=1.13u l=150n m=1
    mp25 (n22 D VDD VDD) pfet_01v8_hvt w=(540n) l=150n m=(1)*(1)
    mp52 (n41 qbint n43 VDD) pfet_01v8_hvt w=(540n) l=150n m=(1)*(1)
    mp51 (n43 RNb VDD VDD) pfet_01v8_hvt w=(540n) l=150n m=(1)*(1)
    mp57 (QN qint VDD VDD) pfet_01v8_hvt w=(620n) l=150n m=(1)*(4)
    mp55 (Q qbint VDD VDD) pfet_01v8_hvt w=1.13u l=150n m=1
    mp36 (n20 CKb n31 VDD) pfet_01v8_hvt w=(540n) l=150n m=(1)*(1)
    mp35 (n31 mout VDD VDD) pfet_01v8_hvt w=(540n) l=150n m=(1)*(1)
    mp32 (mout n20 net402 VDD) pfet_01v8_hvt w=(540n) l=150n m=(1)*(1)
    mp31 (net402 RNb VDD VDD) pfet_01v8_hvt w=(540n) l=150n m=(1)*(1)
    mp22 (RNb RN VDD VDD) pfet_01v8_hvt w=(540n) l=150n m=(1)*(1)
    mp20 (CKb CK VDD VDD) pfet_01v8_hvt w=(540n) l=150n m=(1)*(1)
    mp53 (n35 CKbb n41 VDD) pfet_01v8_hvt w=(540n) l=150n m=(1)*(1)
    mp50 (n41 SN VDD VDD) pfet_01v8_hvt w=(540n) l=150n m=(1)*(1)
    mp45 (qbint n35 VDD VDD) pfet_01v8_hvt w=1.13u l=150n m=1
    mp56 (qint qbint VDD VDD) pfet_01v8_hvt w=1.13u l=150n m=1
    mp21 (CKbb CKb VDD VDD) pfet_01v8_hvt w=(540n) l=150n m=(1)*(1)
    mp30 (mout SN VDD VDD) pfet_01v8_hvt w=(540n) l=150n m=(1)*(1)
    mp40 (n35 CKb mout VDD) pfet_01v8_hvt w=(540n) l=150n m=(1)*(1)
ends DFFSRX4_LP

// sky130_scl_9T_LP/DFFSRX1_LP/schematic
subckt DFFSRX1_LP CK D Q QN RN SN VDD VSS
    mn26 (n20 CKb n21 VSS) nfet_01v8 w=(420n) l=150n m=(1)*(1)
    mn25 (n21 D VSS VSS) nfet_01v8 w=(420n) l=150n m=(1)*(1)
    mn57 (QN qint VSS VSS) nfet_01v8 w=(420n) l=150n m=(1)*(1)
    mn55 (Q qbint VSS VSS) nfet_01v8 w=(420n) l=150n m=(1)*(1)
    mn35 (n30 mout VSS VSS) nfet_01v8 w=(420n) l=150n m=(1)*(1)
    mn36 (n20 CKbb n30 VSS) nfet_01v8 w=(420n) l=150n m=(1)*(1)
    mn22 (RNb RN VSS VSS) nfet_01v8 w=(420n) l=150n m=(1)*(1)
    mn20 (CKb CK VSS VSS) nfet_01v8 w=(420n) l=150n m=(1)*(1)
    mn45 (qbint n35 VSS VSS) nfet_01v8 w=(420n) l=150n m=(1)*(1)
    mn56 (qint qbint VSS VSS) nfet_01v8 w=(420n) l=150n m=(1)*(1)
    mn52 (n40 qbint n42 VSS) nfet_01v8 w=(420n) l=150n m=(1)*(1)
    mn51 (n40 RNb n42 VSS) nfet_01v8 w=(420n) l=150n m=(1)*(1)
    mn50 (n42 SN VSS VSS) nfet_01v8 w=(420n) l=150n m=(1)*(1)
    mn53 (n35 CKb n40 VSS) nfet_01v8 w=(420n) l=150n m=(1)*(1)
    mn21 (CKbb CKb VSS VSS) nfet_01v8 w=(420n) l=150n m=(1)*(1)
    mn32 (mout n20 net426 VSS) nfet_01v8 w=(420n) l=150n m=(1)*(1)
    mn31 (mout RNb net426 VSS) nfet_01v8 w=(420n) l=150n m=(1)*(1)
    mn40 (n35 CKbb mout VSS) nfet_01v8 w=(420n) l=150n m=(1)*(1)
    mn30 (net426 SN VSS VSS) nfet_01v8 w=(420n) l=150n m=(1)*(1)
    mp26 (n20 CKbb n22 VDD) pfet_01v8_hvt w=(540n) l=150n m=(1)*(1)
    mp25 (n22 D VDD VDD) pfet_01v8_hvt w=(540n) l=150n m=(1)*(1)
    mp52 (n41 qbint n43 VDD) pfet_01v8_hvt w=(540n) l=150n m=(1)*(1)
    mp51 (n43 RNb VDD VDD) pfet_01v8_hvt w=(540n) l=150n m=(1)*(1)
    mp57 (QN qint VDD VDD) pfet_01v8_hvt w=(620n) l=150n m=(1)*(1)
    mp55 (Q qbint VDD VDD) pfet_01v8_hvt w=625n l=150n m=1
    mp36 (n20 CKb n31 VDD) pfet_01v8_hvt w=(540n) l=150n m=(1)*(1)
    mp35 (n31 mout VDD VDD) pfet_01v8_hvt w=(540n) l=150n m=(1)*(1)
    mp32 (mout n20 net402 VDD) pfet_01v8_hvt w=(540n) l=150n m=(1)*(1)
    mp31 (net402 RNb VDD VDD) pfet_01v8_hvt w=(540n) l=150n m=(1)*(1)
    mp22 (RNb RN VDD VDD) pfet_01v8_hvt w=(540n) l=150n m=(1)*(1)
    mp20 (CKb CK VDD VDD) pfet_01v8_hvt w=(540n) l=150n m=(1)*(1)
    mp53 (n35 CKbb n41 VDD) pfet_01v8_hvt w=625n l=150n m=1
    mp50 (n41 SN VDD VDD) pfet_01v8_hvt w=(540n) l=150n m=(1)*(1)
    mp45 (qbint n35 VDD VDD) pfet_01v8_hvt w=(540n) l=150n m=(1)*(1)
    mp56 (qint qbint VDD VDD) pfet_01v8_hvt w=(540n) l=150n m=(1)*(1)
    mp21 (CKbb CKb VDD VDD) pfet_01v8_hvt w=(540n) l=150n m=(1)*(1)
    mp30 (mout SN VDD VDD) pfet_01v8_hvt w=(540n) l=150n m=(1)*(1)
    mp40 (n35 CKb mout VDD) pfet_01v8_hvt w=(540n) l=150n m=(1)*(1)
ends DFFSRX1_LP

// sky130_scl_9T_LP/DFFRX4_LP/schematic
subckt DFFRX4_LP CK D Q QN RN VDD VSS
    mn36 (n25 mout n27 VSS) nfet_01v8 w=(420n) l=150n m=(1)*(1)
    mn35 (n27 RN VSS VSS) nfet_01v8 w=(420n) l=150n m=(1)*(1)
    mn37 (n20 CKbb n25 VSS) nfet_01v8 w=(420n) l=150n m=(1)*(1)
    mn26 (n20 CKb n21 VSS) nfet_01v8 w=(420n) l=150n m=(1)*(1)
    mn25 (n21 D VSS VSS) nfet_01v8 w=(420n) l=150n m=(1)*(1)
    mn57 (QN qint VSS VSS) nfet_01v8 w=(420n) l=150n m=(1)*(4)
    mn55 (Q qbint VSS VSS) nfet_01v8 w=(420n) l=150n m=(1)*(4)
    mn45 (n35 RN VSS VSS) nfet_01v8 w=(420n) l=150n m=(1)*(2)
    mn46 (qbint n30 n35 VSS) nfet_01v8 w=(420n) l=150n m=(1)*(2)
    mn51 (n30 CKb n40 VSS) nfet_01v8 w=(420n) l=150n m=(1)*(1)
    mn50 (n40 qbint VSS VSS) nfet_01v8 w=(420n) l=150n m=(1)*(1)
    mn21 (CKbb CKb VSS VSS) nfet_01v8 w=(420n) l=150n m=(1)*(1)
    mn40 (n30 CKbb mout VSS) nfet_01v8 w=(420n) l=150n m=(1)*(1)
    mn30 (mout n20 VSS VSS) nfet_01v8 w=(420n) l=150n m=(1)*(1)
    mn56 (qint qbint VSS VSS) nfet_01v8 w=(420n) l=150n m=(1)*(1)
    mn20 (CKb CK VSS VSS) nfet_01v8 w=(420n) l=150n m=(1)*(1)
    mp26 (n20 CKbb n22 VDD) pfet_01v8_hvt w=(540n) l=150n m=(1)*(1)
    mp25 (n22 D VDD VDD) pfet_01v8_hvt w=(540n) l=150n m=(1)*(1)
    mp51 (n30 CKbb n41 VDD) pfet_01v8_hvt w=(540n) l=150n m=(1)*(1)
    mp50 (n41 qbint VDD VDD) pfet_01v8_hvt w=(540n) l=150n m=(1)*(1)
    mp57 (QN qint VDD VDD) pfet_01v8_hvt w=(620n) l=150n m=(1)*(4)
    mp55 (Q qbint VDD VDD) pfet_01v8_hvt w=1.13u l=150n m=1
    mp20 (CKb CK VDD VDD) pfet_01v8_hvt w=(540n) l=150n m=(1)*(1)
    mp21 (CKbb CKb VDD VDD) pfet_01v8_hvt w=(540n) l=150n m=(1)*(1)
    mp36 (n26 mout VDD VDD) pfet_01v8_hvt w=(540n) l=150n m=(1)*(1)
    mp30 (mout n20 VDD VDD) pfet_01v8_hvt w=(540n) l=150n m=(1)*(1)
    mp35 (n26 RN VDD VDD) pfet_01v8_hvt w=(540n) l=150n m=(1)*(1)
    mp37 (n20 CKb n26 VDD) pfet_01v8_hvt w=1.13u l=150n m=1
    mp46 (qbint n30 VDD VDD) pfet_01v8_hvt w=(540n) l=150n m=(1)*(2)
    mp40 (n30 CKb mout VDD) pfet_01v8_hvt w=(540n) l=150n m=(1)*(1)
    mp45 (qbint RN VDD VDD) pfet_01v8_hvt w=1.13u l=150n m=1
    mp56 (qint qbint VDD VDD) pfet_01v8_hvt w=1.13u l=150n m=1
ends DFFRX4_LP

// sky130_scl_9T_LP/DFFRX1_LP/schematic
subckt DFFRX1_LP CK D Q QN RN VDD VSS
    mn36 (n25 mout n27 VSS) nfet_01v8 w=(420n) l=150n m=(1)*(1)
    mn35 (n27 RN VSS VSS) nfet_01v8 w=(420n) l=150n m=(1)*(1)
    mn37 (n20 CKbb n25 VSS) nfet_01v8 w=(420n) l=150n m=(1)*(1)
    mn26 (n20 CKb n21 VSS) nfet_01v8 w=(420n) l=150n m=(1)*(1)
    mn25 (n21 D VSS VSS) nfet_01v8 w=(420n) l=150n m=(1)*(1)
    mn57 (QN qint VSS VSS) nfet_01v8 w=(420n) l=150n m=(1)*(1)
    mn55 (Q qbint VSS VSS) nfet_01v8 w=(420n) l=150n m=(1)*(1)
    mn45 (n35 RN VSS VSS) nfet_01v8 w=(420n) l=150n m=(1)*(1)
    mn46 (qbint n30 n35 VSS) nfet_01v8 w=(420n) l=150n m=(1)*(1)
    mn51 (n30 CKb n40 VSS) nfet_01v8 w=(420n) l=150n m=(1)*(1)
    mn50 (n40 qbint VSS VSS) nfet_01v8 w=(420n) l=150n m=(1)*(1)
    mn21 (CKbb CKb VSS VSS) nfet_01v8 w=(420n) l=150n m=(1)*(1)
    mn40 (n30 CKbb mout VSS) nfet_01v8 w=(420n) l=150n m=(1)*(1)
    mn30 (mout n20 VSS VSS) nfet_01v8 w=(420n) l=150n m=(1)*(1)
    mn56 (qint qbint VSS VSS) nfet_01v8 w=(420n) l=150n m=(1)*(1)
    mn20 (CKb CK VSS VSS) nfet_01v8 w=(420n) l=150n m=(1)*(1)
    mp26 (n20 CKbb n22 VDD) pfet_01v8_hvt w=(540n) l=150n m=(1)*(1)
    mp25 (n22 D VDD VDD) pfet_01v8_hvt w=(540n) l=150n m=(1)*(1)
    mp51 (n30 CKbb n41 VDD) pfet_01v8_hvt w=(540n) l=150n m=(1)*(1)
    mp50 (n41 qbint VDD VDD) pfet_01v8_hvt w=(540n) l=150n m=(1)*(1)
    mp57 (QN qint VDD VDD) pfet_01v8_hvt w=(620n) l=150n m=(1)*(1)
    mp55 (Q qbint VDD VDD) pfet_01v8_hvt w=1.13u l=150n m=1
    mp20 (CKb CK VDD VDD) pfet_01v8_hvt w=(540n) l=150n m=(1)*(1)
    mp21 (CKbb CKb VDD VDD) pfet_01v8_hvt w=(540n) l=150n m=(1)*(1)
    mp36 (n26 mout VDD VDD) pfet_01v8_hvt w=(540n) l=150n m=(1)*(1)
    mp30 (mout n20 VDD VDD) pfet_01v8_hvt w=(540n) l=150n m=(1)*(1)
    mp35 (n26 RN VDD VDD) pfet_01v8_hvt w=(540n) l=150n m=(1)*(1)
    mp37 (n20 CKb n26 VDD) pfet_01v8_hvt w=1.13u l=150n m=1
    mp46 (qbint n30 VDD VDD) pfet_01v8_hvt w=(540n) l=150n m=(1)*(1)
    mp40 (n30 CKb mout VDD) pfet_01v8_hvt w=(540n) l=150n m=(1)*(1)
    mp45 (qbint RN VDD VDD) pfet_01v8_hvt w=(540n) l=150n m=(1)*(1)
    mp56 (qint qbint VDD VDD) pfet_01v8_hvt w=(540n) l=150n m=(1)*(1)
ends DFFRX1_LP

// sky130_scl_9T_LP/CLKXOR2X1_LP/schematic
subckt CLKXOR2X1_LP A B VDD VSS Y
    mn1 (n2 B VSS VSS) nfet_01v8 w=(420n) l=150n m=(1)*(1)
    mn0 (n1 A VSS VSS) nfet_01v8 w=(420n) l=150n m=(1)*(1)
    mn5 (Y n0 VSS VSS) nfet_01v8 w=(820n) l=150n m=(1)*(4)
    mn3 (n0 B net139 VSS) nfet_01v8 w=(420n) l=150n m=(1)*(1)
    mn4 (n0 n2 n1 VSS) nfet_01v8 w=(420n) l=150n m=(1)*(1)
    mn2 (net139 n1 VSS VSS) nfet_01v8 w=(420n) l=150n m=(1)*(1)
    mp3 (n0 n2 net130 VDD) pfet_01v8_hvt w=(540n) l=150n m=(1)*(1)
    mp1 (n2 B VDD VDD) pfet_01v8_hvt w=(540n) l=150n m=(1)*(1)
    mp4 (n0 B n1 VDD) pfet_01v8_hvt w=1.13u l=150n m=2
    mp0 (n1 A VDD VDD) pfet_01v8_hvt w=(540n) l=150n m=(1)*(1)
    mp5 (Y n0 VDD VDD) pfet_01v8_hvt w=1.13u l=150n m=2
    mp2 (net130 n1 VDD VDD) pfet_01v8_hvt w=(540n) l=150n m=(1)*(1)
ends CLKXOR2X1_LP

// sky130_scl_9T_LP/CLKMX2X2_LP/schematic
subckt CLKMX2X2_LP A B S0 VDD VSS Y
    mn3 (net140 B VSS VSS) nfet_01v8 w=(420n) l=150n m=(1)*(1)
    mn0 (S0b S0 VSS VSS) nfet_01v8 w=(420n) l=150n m=(1)*(1)
    mn2 (n0 S0b net148 VSS) nfet_01v8 w=(420n) l=150n m=(1)*(1)
    mn1 (net148 A VSS VSS) nfet_01v8 w=(420n) l=150n m=(1)*(1)
    mn5 (Y n0 VSS VSS) nfet_01v8 w=(820n) l=150n m=(1)*(4)
    mn4 (n0 S0 net140 VSS) nfet_01v8 w=(420n) l=150n m=(1)*(1)
    mp4 (n0 S0b net115 VDD) pfet_01v8_hvt w=(540n) l=150n m=(1)*(1)
    mp3 (net115 B VDD VDD) pfet_01v8_hvt w=(540n) l=150n m=(1)*(1)
    mp5 (Y n0 VDD VDD) pfet_01v8_hvt w=1.13u l=150n m=2
    mp2 (n0 S0 net123 VDD) pfet_01v8_hvt w=1.13u l=150n m=2
    mp0 (S0b S0 VDD VDD) pfet_01v8_hvt w=(540n) l=150n m=(1)*(1)
    mp1 (net123 A VDD VDD) pfet_01v8_hvt w=(540n) l=150n m=(1)*(1)
ends CLKMX2X2_LP

// sky130_scl_9T_LP/CLKINVX8_LP/schematic
subckt CLKINVX8_LP A VDD VSS Y
    mn0 (Y A VSS VSS) nfet_01v8 w=(420n) l=150n m=(1)*(8)
    mp0 (Y A VDD VDD) pfet_01v8_hvt w=(820n) l=150n m=(1)*(16)
ends CLKINVX8_LP

// sky130_scl_9T_LP/CLKINVX4_LP/schematic
subckt CLKINVX4_LP A VDD VSS Y
    mn0 (Y A VSS VSS) nfet_01v8 w=(420n) l=150n m=(1)*(4)
    mp0 (Y A VDD VDD) pfet_01v8_hvt w=(820n) l=150n m=(1)*(8)
ends CLKINVX4_LP

// sky130_scl_9T_LP/CLKINVX2_LP/schematic
subckt CLKINVX2_LP A VDD VSS Y
    mn0 (Y A VSS VSS) nfet_01v8 w=(420n) l=150n m=(1)*(2)
    mp0 (Y A VDD VDD) pfet_01v8_hvt w=(820n) l=150n m=(1)*(4)
ends CLKINVX2_LP

// sky130_scl_9T_LP/CLKINVX1_LP/schematic
subckt CLKINVX1_LP A VDD VSS Y
    mn0 (Y A VSS VSS) nfet_01v8 w=(420n) l=150n m=(1)*(1)
    mp0 (Y A VDD VDD) pfet_01v8_hvt w=(820n) l=150n m=(1)*(2)
ends CLKINVX1_LP

// sky130_scl_9T_LP/CLKBUFX8_LP/schematic
subckt CLKBUFX8_LP A VDD VSS Y
    mn1 (Y net44 VSS VSS) nfet_01v8 w=(420n) l=150n m=(1)*(8)
    mn0 (net44 A VSS VSS) nfet_01v8 w=(420n) l=150n m=(1)*(2)
    mp1 (Y net44 VDD VDD) pfet_01v8_hvt w=(1.36u) l=150n m=(1)*(8)
    mp0 (net44 A VDD VDD) pfet_01v8_hvt w=(1.36u) l=150n m=(1)*(2)
ends CLKBUFX8_LP

// sky130_scl_9T_LP/CLKBUFX4_LP/schematic
subckt CLKBUFX4_LP A VDD VSS Y
    mn1 (Y net44 VSS VSS) nfet_01v8 w=(420n) l=150n m=(1)*(4)
    mn0 (net44 A VSS VSS) nfet_01v8 w=(1u) l=150n m=(1)*(1)
    mp1 (Y net44 VDD VDD) pfet_01v8_hvt w=(1.36u) l=150n m=(1)*(4)
    mp0 (net44 A VDD VDD) pfet_01v8_hvt w=1.13u l=150n m=4
ends CLKBUFX4_LP

// sky130_scl_9T_LP/CLKBUFX2_LP/schematic
subckt CLKBUFX2_LP A VDD VSS Y
    mn1 (Y net44 VSS VSS) nfet_01v8 w=(420n) l=150n m=(1)*(2)
    mn0 (net44 A VSS VSS) nfet_01v8 w=(840n) l=150n m=(1)*(1)
    mp1 (Y net44 VDD VDD) pfet_01v8_hvt w=(1.36u) l=150n m=(1)*(2)
    mp0 (net44 A VDD VDD) pfet_01v8_hvt w=(1.24u) l=150n m=(1)*(1)
ends CLKBUFX2_LP

// sky130_scl_9T_LP/CLKAND2X2_LP/schematic
subckt CLKAND2X2_LP A B VDD VSS Y
    NM1 (net2 A VSS VSS) nfet_01v8 w=(420n) l=150n m=(1)*(1)
    NM0 (net61 B net2 VSS) nfet_01v8 w=(420n) l=150n m=(1)*(1)
    mn2 (Y net61 VSS VSS) nfet_01v8 w=(820n) l=150n m=(1)*(1)
    mp1 (net61 B VDD VDD) pfet_01v8_hvt w=(540n) l=150n m=(1)*(1)
    mp0 (net61 A VDD VDD) pfet_01v8_hvt w=1.13u l=150n m=2
    mp2 (Y net61 VDD VDD) pfet_01v8_hvt w=1.13u l=150n m=2
ends CLKAND2X2_LP

// sky130_scl_9T_LP/BUFX8_LP/schematic
subckt BUFX8_LP A VDD VSS Y
    mn1 (VSS n0 Y VSS) nfet_01v8 w=(840n) l=150n m=(1)*(4)
    mn0 (VSS A n0 VSS) nfet_01v8 w=(840n) l=150n m=(1)*(1)
    mp1 (Y n0 VDD VDD) pfet_01v8_hvt w=1.13u l=150n m=2
    mp0 (n0 A VDD VDD) pfet_01v8_hvt w=1.13u l=150n m=2
ends BUFX8_LP

// sky130_scl_9T_LP/BUFX4_LP/schematic
subckt BUFX4_LP A VDD VSS Y
    mn1 (VSS n0 Y VSS) nfet_01v8 w=(840n) l=150n m=(1)*(2)
    mn0 (VSS A n0 VSS) nfet_01v8 w=(420n) l=150n m=(1)*(1)
    mp1 (Y n0 VDD VDD) pfet_01v8_hvt w=625n l=150n m=1
    mp0 (n0 A VDD VDD) pfet_01v8_hvt w=625n l=150n m=1
ends BUFX4_LP

// sky130_scl_9T_LP/BUFX2_LP/schematic
subckt BUFX2_LP A VDD VSS Y
    mn1 (VSS n0 Y VSS) nfet_01v8 w=(420n) l=150n m=(1)*(2)
    mn0 (VSS A n0 VSS) nfet_01v8 w=(420n) l=150n m=(1)*(1)
    mp1 (Y n0 VDD VDD) pfet_01v8_hvt w=(620n) l=150n m=(1)*(2)
    mp0 (n0 A VDD VDD) pfet_01v8_hvt w=(540n) l=150n m=(1)*(1)
ends BUFX2_LP

// sky130_scl_9T_LP/BUFX16_LP/schematic
subckt BUFX16_LP A VDD VSS Y
    mn1 (VSS n0 Y VSS) nfet_01v8 w=(840n) l=150n m=(1)*(8)
    mn0 (VSS A n0 VSS) nfet_01v8 w=(840n) l=150n m=(1)*(2)
    mp1 (Y n0 VDD VDD) pfet_01v8_hvt w=625n l=150n m=1
    mp0 (n0 A VDD VDD) pfet_01v8_hvt w=625n l=150n m=1
ends BUFX16_LP

// sky130_scl_9T_LP/AOI22X2_LP/schematic
subckt AOI22X2_LP A0 A1 B0 B1 VDD VSS Y
    mn3 (Y B1 net106 VSS) nfet_01v8 w=(840n) l=150n m=(1)*(1)
    mn0 (net98 A0 VSS VSS) nfet_01v8 w=(840n) l=150n m=(1)*(1)
    mn2 (net106 B0 VSS VSS) nfet_01v8 w=(840n) l=150n m=(1)*(1)
    mn1 (Y A1 net98 VSS) nfet_01v8 w=(840n) l=150n m=(1)*(1)
    mp3 (Y B1 net89 VDD) pfet_01v8_hvt w=(1.24u) l=150n m=(1)*(1)
    mp0 (net89 A0 VDD VDD) pfet_01v8_hvt w=(1.24u) l=150n m=(1)*(1)
    mp1 (net89 A1 VDD VDD) pfet_01v8_hvt w=(1.24u) l=150n m=(1)*(1)
    mp2 (Y B0 net89 VDD) pfet_01v8_hvt w=1.13u l=150n m=1
ends AOI22X2_LP

// sky130_scl_9T_LP/AOI22X1_LP/schematic
subckt AOI22X1_LP A0 A1 B0 B1 VDD VSS Y
    mn3 (Y B1 net98 VSS) nfet_01v8 w=(420n) l=150n m=(1)*(1)
    mn0 (net102 A0 VSS VSS) nfet_01v8 w=(420n) l=150n m=(1)*(1)
    mn2 (net98 B0 VSS VSS) nfet_01v8 w=(420n) l=150n m=(1)*(1)
    mn1 (Y A1 net102 VSS) nfet_01v8 w=(420n) l=150n m=(1)*(1)
    mp3 (Y B1 net89 VDD) pfet_01v8_hvt w=(620n) l=150n m=(1)*(1)
    mp0 (net89 A0 VDD VDD) pfet_01v8_hvt w=(620n) l=150n m=(1)*(1)
    mp1 (net89 A1 VDD VDD) pfet_01v8_hvt w=(620n) l=150n m=(1)*(1)
    mp2 (Y B0 net89 VDD) pfet_01v8_hvt w=1.13u l=150n m=1
ends AOI22X1_LP

// sky130_scl_9T_LP/AOI222X2_LP/schematic
subckt AOI222X2_LP A0 A1 B0 B1 C0 C1 VDD VSS Y
    mn5 (Y C1 net155 VSS) nfet_01v8 w=(840n) l=150n m=(1)*(1)
    mn4 (net155 C0 VSS VSS) nfet_01v8 w=(840n) l=150n m=(1)*(1)
    mn2 (net151 B0 VSS VSS) nfet_01v8 w=(840n) l=150n m=(1)*(1)
    mn0 (net147 A0 VSS VSS) nfet_01v8 w=(840n) l=150n m=(1)*(1)
    mn1 (Y A1 net147 VSS) nfet_01v8 w=(840n) l=150n m=(1)*(1)
    mn3 (Y B1 net151 VSS) nfet_01v8 w=(840n) l=150n m=(1)*(1)
    mp5 (Y C1 net134 VDD) pfet_01v8_hvt w=(1.24u) l=150n m=(1)*(1)
    mp4 (Y C0 net134 VDD) pfet_01v8_hvt w=1.13u l=150n m=1
    mp3 (net134 B1 net126 VDD) pfet_01v8_hvt w=(1.24u) l=150n m=(1)*(1)
    mp2 (net134 B0 net126 VDD) pfet_01v8_hvt w=(1.24u) l=150n m=(1)*(1)
    mp0 (net126 A0 VDD VDD) pfet_01v8_hvt w=(1.24u) l=150n m=(1)*(1)
    mp1 (net126 A1 VDD VDD) pfet_01v8_hvt w=(1.24u) l=150n m=(1)*(1)
ends AOI222X2_LP

// sky130_scl_9T_LP/AOI222X1_LP/schematic
subckt AOI222X1_LP A0 A1 B0 B1 C0 C1 VDD VSS Y
    mn5 (Y C1 net155 VSS) nfet_01v8 w=(420n) l=150n m=(1)*(1)
    mn4 (net155 C0 VSS VSS) nfet_01v8 w=(420n) l=150n m=(1)*(1)
    mn2 (net147 B0 VSS VSS) nfet_01v8 w=(420n) l=150n m=(1)*(1)
    mn0 (net139 A0 VSS VSS) nfet_01v8 w=(420n) l=150n m=(1)*(1)
    mn1 (Y A1 net139 VSS) nfet_01v8 w=(420n) l=150n m=(1)*(1)
    mn3 (Y B1 net147 VSS) nfet_01v8 w=(420n) l=150n m=(1)*(1)
    mp5 (Y C1 net118 VDD) pfet_01v8_hvt w=(620n) l=150n m=(1)*(1)
    mp4 (Y C0 net118 VDD) pfet_01v8_hvt w=1.13u l=150n m=1
    mp3 (net118 B1 net122 VDD) pfet_01v8_hvt w=(620n) l=150n m=(1)*(1)
    mp2 (net118 B0 net122 VDD) pfet_01v8_hvt w=(620n) l=150n m=(1)*(1)
    mp0 (net122 A0 VDD VDD) pfet_01v8_hvt w=(620n) l=150n m=(1)*(1)
    mp1 (net122 A1 VDD VDD) pfet_01v8_hvt w=(620n) l=150n m=(1)*(1)
ends AOI222X1_LP

// sky130_scl_9T_LP/AOI221X2_LP/schematic
subckt AOI221X2_LP A0 A1 B0 B1 C0 VDD VSS Y
    mn2 (Y B0 net116 VSS) nfet_01v8 w=(420n) l=150n m=(1)*(2)
    mn3 (net116 B1 VSS VSS) nfet_01v8 w=(420n) l=150n m=(1)*(2)
    mn4 (Y C0 VSS VSS) nfet_01v8 w=(420n) l=150n m=(1)*(2)
    mn1 (Y A1 net124 VSS) nfet_01v8 w=(420n) l=150n m=(1)*(2)
    mn0 (net124 A0 VSS VSS) nfet_01v8 w=(420n) l=150n m=(1)*(2)
    mp3 (net104 B1 net103 VDD) pfet_01v8_hvt w=(620n) l=150n m=(1)*(2)
    mp2 (net104 B0 net103 VDD) pfet_01v8_hvt w=(620n) l=150n m=(1)*(2)
    mp0 (net103 A0 VDD VDD) pfet_01v8_hvt w=(620n) l=150n m=(1)*(2)
    mp1 (net103 A1 VDD VDD) pfet_01v8_hvt w=(620n) l=150n m=(1)*(2)
    mp4 (Y C0 net104 VDD) pfet_01v8_hvt w=625n l=150n m=1
ends AOI221X2_LP

// sky130_scl_9T_LP/AOI221X1_LP/schematic
subckt AOI221X1_LP A0 A1 B0 B1 C0 VDD VSS Y
    mn2 (net120 B0 VSS VSS) nfet_01v8 w=(420n) l=150n m=(1)*(1)
    mn3 (Y B1 net120 VSS) nfet_01v8 w=(420n) l=150n m=(1)*(1)
    mn4 (Y C0 VSS VSS) nfet_01v8 w=(420n) l=150n m=(1)*(1)
    mn1 (Y A1 net128 VSS) nfet_01v8 w=(420n) l=150n m=(1)*(1)
    mn0 (net128 A0 VSS VSS) nfet_01v8 w=(420n) l=150n m=(1)*(1)
    mp3 (net108 B1 net111 VDD) pfet_01v8_hvt w=(620n) l=150n m=(1)*(1)
    mp2 (net108 B0 net111 VDD) pfet_01v8_hvt w=(620n) l=150n m=(1)*(1)
    mp0 (net111 A0 VDD VDD) pfet_01v8_hvt w=(620n) l=150n m=(1)*(1)
    mp1 (net111 A1 VDD VDD) pfet_01v8_hvt w=(620n) l=150n m=(1)*(1)
    mp4 (Y C0 net108 VDD) pfet_01v8_hvt w=1.13u l=150n m=1
ends AOI221X1_LP

// sky130_scl_9T_LP/AOI21X2_LP/schematic
subckt AOI21X2_LP A0 A1 B0 VDD VSS Y
    mn2 (Y B0 VSS VSS) nfet_01v8 w=(840n) l=150n m=(1)*(1)
    mn0 (net74 A0 VSS VSS) nfet_01v8 w=(840n) l=150n m=(1)*(1)
    mn1 (Y A1 net74 VSS) nfet_01v8 w=(840n) l=150n m=(1)*(1)
    mp2 (Y B0 net70 VDD) pfet_01v8_hvt w=1.13u l=150n m=1
    mp1 (net70 A1 VDD VDD) pfet_01v8_hvt w=(1.24u) l=150n m=(1)*(1)
    mp0 (net70 A0 VDD VDD) pfet_01v8_hvt w=(1.24u) l=150n m=(1)*(1)
ends AOI21X2_LP

// sky130_scl_9T_LP/AOI21X1_LP/schematic
subckt AOI21X1_LP A0 A1 B0 VDD VSS Y
    mn2 (Y B0 VSS VSS) nfet_01v8 w=(420n) l=150n m=(1)*(1)
    mn0 (net78 A0 VSS VSS) nfet_01v8 w=(420n) l=150n m=(1)*(1)
    mn1 (Y A1 net78 VSS) nfet_01v8 w=(420n) l=150n m=(1)*(1)
    mp2 (Y B0 net62 VDD) pfet_01v8_hvt w=(620n) l=150n m=(1)*(1)
    mp1 (net62 A1 VDD VDD) pfet_01v8_hvt w=(620n) l=150n m=(1)*(1)
    mp0 (net62 A0 VDD VDD) pfet_01v8_hvt w=1.13u l=150n m=1
ends AOI21X1_LP

// sky130_scl_9T_LP/AOI211X2_LP/schematic
subckt AOI211X2_LP A0 A1 B0 C0 VDD VSS Y
    mn2 (Y B0 VSS VSS) nfet_01v8 w=(840n) l=150n m=(1)*(1)
    mn3 (Y C0 VSS VSS) nfet_01v8 w=(840n) l=150n m=(1)*(1)
    mn1 (Y A1 net95 VSS) nfet_01v8 w=(840n) l=150n m=(1)*(1)
    mn0 (net95 A0 VSS VSS) nfet_01v8 w=(840n) l=150n m=(1)*(1)
    mp3 (Y C0 net82 VDD) pfet_01v8_hvt w=1.13u l=150n m=1
    mp2 (net82 B0 net91 VDD) pfet_01v8_hvt w=(1.24u) l=150n m=(1)*(1)
    mp1 (net91 A1 VDD VDD) pfet_01v8_hvt w=(1.24u) l=150n m=(1)*(1)
    mp0 (net91 A0 VDD VDD) pfet_01v8_hvt w=(1.24u) l=150n m=(1)*(1)
ends AOI211X2_LP

// sky130_scl_9T_LP/AOI211X1_LP/schematic
subckt AOI211X1_LP A0 A1 B0 C0 VDD VSS Y
    mn2 (Y B0 VSS VSS) nfet_01v8 w=(420n) l=150n m=(1)*(1)
    mn3 (Y C0 VSS VSS) nfet_01v8 w=(420n) l=150n m=(1)*(1)
    mn1 (Y A1 net95 VSS) nfet_01v8 w=(420n) l=150n m=(1)*(1)
    mn0 (net95 A0 VSS VSS) nfet_01v8 w=(420n) l=150n m=(1)*(1)
    mp3 (Y C0 net82 VDD) pfet_01v8_hvt w=1.13u l=150n m=1
    mp2 (net82 B0 net91 VDD) pfet_01v8_hvt w=(620n) l=150n m=(1)*(1)
    mp1 (net91 A1 VDD VDD) pfet_01v8_hvt w=(620n) l=150n m=(1)*(1)
    mp0 (net91 A0 VDD VDD) pfet_01v8_hvt w=(620n) l=150n m=(1)*(1)
ends AOI211X1_LP

// sky130_scl_9T_LP/AND4X2_LP/schematic
subckt AND4X2_LP A B C D VDD VSS Y
    mn3 (net100 D net132 VSS) nfet_01v8 w=(420n) l=150n m=(1)*(1)
    mn2 (net132 C net124 VSS) nfet_01v8 w=(420n) l=150n m=(1)*(1)
    mn4 (Y net100 VSS VSS) nfet_01v8 w=(840n) l=150n m=(1)*(1)
    mn1 (net124 B net120 VSS) nfet_01v8 w=(420n) l=150n m=(1)*(1)
    mn0 (net120 A VSS VSS) nfet_01v8 w=(420n) l=150n m=(1)*(1)
    mp3 (net100 D VDD VDD) pfet_01v8_hvt w=(540n) l=150n m=(1)*(1)
    mp2 (net100 C VDD VDD) pfet_01v8_hvt w=(540n) l=150n m=(1)*(1)
    mp1 (net100 B VDD VDD) pfet_01v8_hvt w=(540n) l=150n m=(1)*(1)
    mp4 (Y net100 VDD VDD) pfet_01v8_hvt w=625n l=150n m=1
    mp0 (net100 A VDD VDD) pfet_01v8_hvt w=625n l=150n m=1
ends AND4X2_LP

// sky130_scl_9T_LP/AND4X1_LP/schematic
subckt AND4X1_LP A B C D VDD VSS Y
    mn3 (net116 D net132 VSS) nfet_01v8 w=(420n) l=150n m=(1)*(1)
    mn2 (net132 C net128 VSS) nfet_01v8 w=(420n) l=150n m=(1)*(1)
    mn4 (Y net116 VSS VSS) nfet_01v8 w=(420n) l=150n m=(1)*(1)
    mn1 (net128 B net124 VSS) nfet_01v8 w=(420n) l=150n m=(1)*(1)
    mn0 (net124 A VSS VSS) nfet_01v8 w=(420n) l=150n m=(1)*(1)
    mp3 (net116 D VDD VDD) pfet_01v8_hvt w=(540n) l=150n m=(1)*(1)
    mp2 (net116 C VDD VDD) pfet_01v8_hvt w=(540n) l=150n m=(1)*(1)
    mp1 (net116 B VDD VDD) pfet_01v8_hvt w=(540n) l=150n m=(1)*(1)
    mp4 (Y net116 VDD VDD) pfet_01v8_hvt w=625n l=150n m=1
    mp0 (net116 A VDD VDD) pfet_01v8_hvt w=625n l=150n m=1
ends AND4X1_LP

// sky130_scl_9T_LP/AND3X2_LP/schematic
subckt AND3X2_LP A B C VDD VSS Y
    mn3 (Y net95 VSS VSS) nfet_01v8 w=(840n) l=150n m=(1)*(1)
    mn1 (net111 B net103 VSS) nfet_01v8 w=(420n) l=150n m=(1)*(1)
    mn0 (net103 A VSS VSS) nfet_01v8 w=(420n) l=150n m=(1)*(1)
    mn2 (net95 C net111 VSS) nfet_01v8 w=(420n) l=150n m=(1)*(1)
    mp1 (net95 B VDD VDD) pfet_01v8_hvt w=(540n) l=150n m=(1)*(1)
    mp2 (net95 C VDD VDD) pfet_01v8_hvt w=(540n) l=150n m=(1)*(1)
    mp0 (net95 A VDD VDD) pfet_01v8_hvt w=1.13u l=150n m=1
    mp3 (Y net95 VDD VDD) pfet_01v8_hvt w=1.13u l=150n m=1
ends AND3X2_LP

// sky130_scl_9T_LP/AND3X1_LP/schematic
subckt AND3X1_LP A B C VDD VSS Y
    mn3 (Y net086 VSS VSS) nfet_01v8 w=(420n) l=150n m=(1)*(1)
    mn1 (net0106 B net0102 VSS) nfet_01v8 w=(420n) l=150n m=(1)*(1)
    mn0 (net0102 A VSS VSS) nfet_01v8 w=(420n) l=150n m=(1)*(1)
    mn2 (net086 C net0106 VSS) nfet_01v8 w=(420n) l=150n m=(1)*(1)
    mp1 (net086 B VDD VDD) pfet_01v8_hvt w=(540n) l=150n m=(1)*(1)
    mp2 (net086 C VDD VDD) pfet_01v8_hvt w=(540n) l=150n m=(1)*(1)
    mp0 (net086 A VDD VDD) pfet_01v8_hvt w=1.13u l=150n m=2
    mp3 (Y net086 VDD VDD) pfet_01v8_hvt w=1.13u l=150n m=2
ends AND3X1_LP

// sky130_scl_9T_LP/AND2X2_LP/schematic
subckt AND2X2_LP A B VDD VSS Y
    mn2 (Y n0 VSS VSS) nfet_01v8 w=(420n) l=150n m=(1)*(2)
    mn0 (net73 A VSS VSS) nfet_01v8 w=(420n) l=150n m=(1)*(1)
    mn1 (n0 B net73 VSS) nfet_01v8 w=(420n) l=150n m=(1)*(1)
    mp1 (n0 B VDD VDD) pfet_01v8_hvt w=(540n) l=150n m=(1)*(1)
    mp0 (n0 A VDD VDD) pfet_01v8_hvt w=1.13u l=150n m=2
    mp2 (Y n0 VDD VDD) pfet_01v8_hvt w=1.13u l=150n m=2
ends AND2X2_LP

// sky130_scl_9T_LP/AND2X1_LP/schematic
subckt AND2X1_LP A B VDD VSS Y
    mn2 (Y n0 VSS VSS) nfet_01v8 w=(420n) l=150n m=(1)*(1)
    mn0 (net127 B VSS VSS) nfet_01v8 w=(420n) l=150n m=(1)*(1)
    mn1 (n0 A net127 VSS) nfet_01v8 w=(420n) l=150n m=(1)*(1)
    mp1 (n0 B VDD VDD) pfet_01v8_hvt w=(540n) l=150n m=(1)*(1)
    mp0 (n0 A VDD VDD) pfet_01v8_hvt w=1.13u l=150n m=2
    mp2 (Y n0 VDD VDD) pfet_01v8_hvt w=1.13u l=150n m=2
ends AND2X1_LP

// sky130_scl_9T_LP/ADDHX1_LP/schematic
subckt ADDHX1_LP A B CO S VDD VSS
    mn8 (CO COb VSS VSS) nfet_01v8 w=(420n) l=150n m=(1)*(1)
    mn7 (COb B n4 VSS) nfet_01v8 w=(420n) l=150n m=(1)*(1)
    mn6 (n4 A VSS VSS) nfet_01v8 w=(420n) l=150n m=(1)*(1)
    mn5 (S Sb VSS VSS) nfet_01v8 w=(420n) l=150n m=(1)*(1)
    mn3 (Sb B n2 VSS) nfet_01v8 w=(420n) l=150n m=(1)*(1)
    mn2 (n2 n0 VSS VSS) nfet_01v8 w=(420n) l=150n m=(1)*(1)
    mn1 (n1 B VSS VSS) nfet_01v8 w=(420n) l=150n m=(1)*(1)
    mn4 (Sb n1 n0 VSS) nfet_01v8 w=(420n) l=150n m=(1)*(1)
    mn0 (n0 A VSS VSS) nfet_01v8 w=(420n) l=150n m=(1)*(1)
    mp8 (CO COb VDD VDD) pfet_01v8_hvt w=(620n) l=150n m=(1)*(1)
    mp5 (S Sb VDD VDD) pfet_01v8_hvt w=1.13u l=150n m=1
    mp2 (n3 n0 VDD VDD) pfet_01v8_hvt w=(540n) l=150n m=(1)*(1)
    mp3 (Sb n1 n3 VDD) pfet_01v8_hvt w=1.13u l=150n m=1
    mp4 (Sb B n0 VDD) pfet_01v8_hvt w=(540n) l=150n m=(1)*(1)
    mp1 (n1 B VDD VDD) pfet_01v8_hvt w=(540n) l=150n m=(1)*(1)
    mp7 (COb B VDD VDD) pfet_01v8_hvt w=(540n) l=150n m=(1)*(1)
    mp0 (n0 A VDD VDD) pfet_01v8_hvt w=(540n) l=150n m=(1)*(1)
    mp6 (COb A VDD VDD) pfet_01v8_hvt w=(540n) l=150n m=(1)*(1)
ends ADDHX1_LP

// sky130_scl_9T_LP/ADDFX1_LP/schematic
subckt ADDFX1_LP A B CI CO S VDD VSS
    mn9 (n6 A VSS VSS) nfet_01v8 w=(420n) l=150n m=(1)*(1)
    mn10 (n7 B n6 VSS) nfet_01v8 w=(420n) l=150n m=(1)*(1)
    mn11 (Sb CI n7 VSS) nfet_01v8 w=(420n) l=150n m=(1)*(1)
    mn13 (S Sb VSS VSS) nfet_01v8 w=(420n) l=150n m=(1)*(1)
    mn12 (CO COb VSS VSS) nfet_01v8 w=(420n) l=150n m=(1)*(1)
    mn1 (COb B n0 VSS) nfet_01v8 w=(420n) l=150n m=(1)*(1)
    mn2 (n2 A VSS VSS) nfet_01v8 w=(420n) l=150n m=(1)*(1)
    mn0 (n0 A VSS VSS) nfet_01v8 w=(420n) l=150n m=(1)*(1)
    mn7 (n4 CI VSS VSS) nfet_01v8 w=(420n) l=150n m=(1)*(1)
    mn8 (Sb COb n4 VSS) nfet_01v8 w=(420n) l=150n m=(1)*(1)
    mn3 (n2 B VSS VSS) nfet_01v8 w=(420n) l=150n m=(1)*(1)
    mn6 (n4 B VSS VSS) nfet_01v8 w=(420n) l=150n m=(1)*(1)
    mn5 (n4 A VSS VSS) nfet_01v8 w=(420n) l=150n m=(1)*(1)
    mn4 (COb CI n2 VSS) nfet_01v8 w=(420n) l=150n m=(1)*(1)
    mp9 (n8 A VDD VDD) pfet_01v8_hvt w=(540n) l=150n m=(1)*(1)
    mp10 (n9 B n8 VDD) pfet_01v8_hvt w=(540n) l=150n m=(1)*(1)
    mp11 (Sb CI n9 VDD) pfet_01v8_hvt w=1.13u l=150n m=2
    mp13 (S Sb VDD VDD) pfet_01v8_hvt w=(620n) l=150n m=(1)*(1)
    mp12 (CO COb VDD VDD) pfet_01v8_hvt w=1.13u l=150n m=2
    mp1 (COb B n1 VDD) pfet_01v8_hvt w=(540n) l=150n m=(1)*(1)
    mp0 (n1 A VDD VDD) pfet_01v8_hvt w=(540n) l=150n m=(1)*(1)
    mp2 (n3 A VDD VDD) pfet_01v8_hvt w=(540n) l=150n m=(1)*(1)
    mp4 (COb CI n3 VDD) pfet_01v8_hvt w=(540n) l=150n m=(1)*(1)
    mp5 (n5 A VDD VDD) pfet_01v8_hvt w=(540n) l=150n m=(1)*(1)
    mp6 (n5 B VDD VDD) pfet_01v8_hvt w=(540n) l=150n m=(1)*(1)
    mp7 (n5 CI VDD VDD) pfet_01v8_hvt w=(540n) l=150n m=(1)*(1)
    mp3 (n3 B VDD VDD) pfet_01v8_hvt w=(540n) l=150n m=(1)*(1)
    mp8 (Sb COb n5 VDD) pfet_01v8_hvt w=(540n) l=150n m=(1)*(1)
ends ADDFX1_LP
