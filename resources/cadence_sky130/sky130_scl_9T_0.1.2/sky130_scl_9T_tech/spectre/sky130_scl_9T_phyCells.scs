// sky130_scl_9T_phyCells/ANTENNA/schematic
subckt ANTENNA A VDD VSS
    D0 (A VDD) diode_pd2nw_05v5 area=1e-12 pj=4e-06 m=1
    D1 (VSS A) diode_pw2nd_05v5 area=0.36 pj=2.4 m=1
ends ANTENNA

// sky130_scl_9T_phyCells/FILL_DECAP8/schematic
subckt FILL_DECAP8 VDD VSS
    NM0 (VSS VDD VSS VSS) nfet_01v8 w=(2.8u) l=2.1u m=(1)*(1)
ends FILL_DECAP8

// sky130_scl_9T_phyCells/FILL_DECAP16/schematic
subckt FILL_DECAP16 VDD VSS
    NM0 (VSS VDD VSS VSS) nfet_01v8 w=(2.8u) l=5.78u m=(1)*(1)
ends FILL_DECAP16

// sky130_scl_9T_phyCells/TIELO/schematic
subckt TIELO VDD VSS Y
    mp0 (net1 net1 VDD VDD) pfet_01v8 w=(1.13u) l=150n m=(1)*(1)
    mn0 (Y net1 VSS VSS) nfet_01v8 w=(760n) l=150n m=(1)*(1)
ends TIELO

// sky130_scl_9T_phyCells/TIEHI/schematic
subckt TIEHI VDD VSS Y
    mp0 (Y net1 VDD VDD) pfet_01v8 w=(1.13u) l=150n m=(1)*(1)
    mn0 (net1 net1 VSS VSS) nfet_01v8 w=(760n) l=150n m=(1)*(1)
ends TIEHI
